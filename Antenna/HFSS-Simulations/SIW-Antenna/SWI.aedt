# Ansys Electronics Desktop project, version 2020.2
materials:
  vacuum: permittivity=1
  Rogers RO4003 (tm): permittivity=3.55 dielectric_loss_tangent=0.0027
  copper: permeability=0.999991 conductivity=58000000

design HFSSDesign1 (HFSS, DrivenModal, model units mm)
options: Calculate_Lossy_Dielectrics
variables:
  gap = 1.524mm
  p = 0.7mm
  Wx = 14mm
  Lt = 4.5mm
  Lm = 2mm
  beta = -50deg
  a = 4mm
  var = 11mm
  dy = 3mm
  Xs = 0.95mm
  S1 = 0.7mm
  Xy = 6mm
  Xslot = 2mm
  Yslot = 1mm
  Wslot = 0.2mm
  slot_move = -1mm
  bettta = 180deg
  angell = 72.758258deg
  Ln = 10.5mm
geometry:
  Box6 [vacuum] = box(corner=(-10mm, -10mm, -10mm), size=(20mm, 50mm, 20mm))
  coordinate_system RelativeCS1 = origin=(a/2, -Lt, 0mm) x=(1mm, 0mm, 0mm) y=(0mm, 1mm, 0mm)
  coordinate_system RelativeCS2 = origin=(a/2, -Lt, 0mm) x=(1mm, 0mm, 0mm) y=(0mm, 1mm, 0mm)
  Rectangle3 = rectangle(corner=(-a/2, -Lt-Lm, -gap/2), z_size=gap+.2mm, x_size=a)
  Rectangle7 [copper] = rectangle(corner=(-Wx/2, 0, gap/2-35um), x_size=Wx, y_size=13.5*p)
  Rectangle7.thicken(35um)
  Rectangle7_1 = Rectangle7.duplicate_around_axis(axis=Y, angle=180deg, total=2)
  coordinate_system RelativeCS3 = origin=(a/2, -Lt, 0mm) x=(1mm, 0mm, 0mm) y=(0mm, 1mm, 0mm)
  Rectangle8 = rectangle(corner=(Wx/2, 13.5*p, gap/2), x_size=-2mm, y_size=Ln)
  Rectangle8.thicken(35um)
  Rectangle8_1 = Rectangle8.duplicate_around_axis(axis=Y, angle=180deg, total=2)
  Rectangle9 = rectangle(corner=(-Wx/2, 13.5*p, gap/2-35um), x_size=2mm, y_size=Ln)
  Rectangle9.thicken(35um)
  Rectangle9_1 = Rectangle9.duplicate_around_axis(axis=Y, angle=180deg, total=2)
  Cylinder2 = cylinder(axis=Z, base_centre=(a/2, -Lt, -gap/1.9), radius=0.15mm, height=2*gap/1.9)
  Cylinder1_11, Cylinder1_12 = Cylinder2.duplicate_along_line(step=(0mm, -p, 0mm), total=3)
  Cylinder1_1_2 = Cylinder1_11.duplicate_mirror(point=(0mm, 0mm, 0mm), normal=(1mm, 0mm, 0mm))
  Cylinder1_2_2 = Cylinder1_12.duplicate_mirror(point=(0mm, 0mm, 0mm), normal=(1mm, 0mm, 0mm))
  Cylinder1_13..Cylinder1_19 = Cylinder2.duplicate_along_line(step=(0mm, p, 0mm), total=8) in RelativeCS3
  Cylinder1_13.rotate(axis=Z, angle=beta) in RelativeCS3
  Cylinder1_3_2 = Cylinder1_13.duplicate_mirror(point=(0mm, 0mm, 0mm), normal=(1mm, 0mm, 0mm))
  Cylinder1_14.rotate(axis=Z, angle=beta) in RelativeCS3
  Cylinder1_4_2 = Cylinder1_14.duplicate_mirror(point=(0mm, 0mm, 0mm), normal=(1mm, 0mm, 0mm))
  Cylinder1_15.rotate(axis=Z, angle=beta) in RelativeCS3
  Cylinder1_5_2 = Cylinder1_15.duplicate_mirror(point=(0mm, 0mm, 0mm), normal=(1mm, 0mm, 0mm))
  Cylinder1_16.rotate(axis=Z, angle=beta) in RelativeCS3
  Cylinder1_6_2 = Cylinder1_16.duplicate_mirror(point=(0mm, 0mm, 0mm), normal=(1mm, 0mm, 0mm))
  Cylinder1_17.rotate(axis=Z, angle=beta) in RelativeCS3
  Cylinder1_7_2 = Cylinder1_17.duplicate_mirror(point=(0mm, 0mm, 0mm), normal=(1mm, 0mm, 0mm))
  Cylinder1_18.rotate(axis=Z, angle=beta) in RelativeCS3
  Cylinder1_8_2 = Cylinder1_18.duplicate_mirror(point=(0mm, 0mm, 0mm), normal=(1mm, 0mm, 0mm))
  Cylinder1_19.rotate(axis=Z, angle=beta) in RelativeCS3
  Cylinder1_9_32 = Cylinder1_19.duplicate_mirror(point=(0mm, 0mm, 0mm), normal=(1mm, 0mm, 0mm))
  Cylinder1_9_33..Cylinder1_9_62 = Cylinder1_19.duplicate_along_line(step=(0mm, p, 0mm), total=31)
  Cylinder1_9_2_2 = Cylinder1_9_33.duplicate_mirror(point=(0mm, -8mm, 0.1mm), normal=(1mm, 1.812609e-15mm, -1.699321e-16mm))
  Cylinder1_9_3_2 = Cylinder1_9_34.duplicate_mirror(point=(0mm, -8mm, 0.1mm), normal=(1mm, 1.812609e-15mm, -1.699321e-16mm))
  Cylinder1_9_4_2 = Cylinder1_9_35.duplicate_mirror(point=(0mm, -8mm, 0.1mm), normal=(1mm, 1.812609e-15mm, -1.699321e-16mm))
  Cylinder1_9_5_2 = Cylinder1_9_36.duplicate_mirror(point=(0mm, -8mm, 0.1mm), normal=(1mm, 1.812609e-15mm, -1.699321e-16mm))
  Cylinder1_9_6_2 = Cylinder1_9_37.duplicate_mirror(point=(0mm, -8mm, 0.1mm), normal=(1mm, 1.812609e-15mm, -1.699321e-16mm))
  Cylinder1_9_7_2 = Cylinder1_9_38.duplicate_mirror(point=(0mm, -8mm, 0.1mm), normal=(1mm, 1.812609e-15mm, -1.699321e-16mm))
  Cylinder1_9_8_2 = Cylinder1_9_39.duplicate_mirror(point=(0mm, -8mm, 0.1mm), normal=(1mm, 1.812609e-15mm, -1.699321e-16mm))
  Cylinder1_9_9_2 = Cylinder1_9_40.duplicate_mirror(point=(0mm, -8mm, 0.1mm), normal=(1mm, 1.812609e-15mm, -1.699321e-16mm))
  Cylinder1_9_10_2 = Cylinder1_9_41.duplicate_mirror(point=(0mm, -8mm, 0.1mm), normal=(1mm, 1.812609e-15mm, -1.699321e-16mm))
  Cylinder1_9_11_2 = Cylinder1_9_42.duplicate_mirror(point=(0mm, -8mm, 0.1mm), normal=(1mm, 1.812609e-15mm, -1.699321e-16mm))
  Cylinder1_9_12_2 = Cylinder1_9_43.duplicate_mirror(point=(0mm, -8mm, 0.1mm), normal=(1mm, 1.812609e-15mm, -1.699321e-16mm))
  Cylinder1_9_13_2 = Cylinder1_9_44.duplicate_mirror(point=(0mm, -8mm, 0.1mm), normal=(1mm, 1.812609e-15mm, -1.699321e-16mm))
  Cylinder1_9_14_2 = Cylinder1_9_45.duplicate_mirror(point=(0mm, -8mm, 0.1mm), normal=(1mm, 1.812609e-15mm, -1.699321e-16mm))
  Cylinder1_9_15_2 = Cylinder1_9_46.duplicate_mirror(point=(0mm, -8mm, 0.1mm), normal=(1mm, 1.812609e-15mm, -1.699321e-16mm))
  Cylinder1_9_16_2 = Cylinder1_9_47.duplicate_mirror(point=(0mm, -8mm, 0.1mm), normal=(1mm, 1.812609e-15mm, -1.699321e-16mm))
  Cylinder1_9_17_2 = Cylinder1_9_48.duplicate_mirror(point=(0mm, -8mm, 0.1mm), normal=(1mm, 1.812609e-15mm, -1.699321e-16mm))
  Cylinder1_9_18_2 = Cylinder1_9_49.duplicate_mirror(point=(0mm, -8mm, 0.1mm), normal=(1mm, 1.812609e-15mm, -1.699321e-16mm))
  Cylinder1_9_19_2 = Cylinder1_9_50.duplicate_mirror(point=(0mm, -8mm, 0.1mm), normal=(1mm, 1.812609e-15mm, -1.699321e-16mm))
  Cylinder1_9_20_2 = Cylinder1_9_51.duplicate_mirror(point=(0mm, -8mm, 0.1mm), normal=(1mm, 1.812609e-15mm, -1.699321e-16mm))
  Cylinder1_9_21_2 = Cylinder1_9_52.duplicate_mirror(point=(0mm, -8mm, 0.1mm), normal=(1mm, 1.812609e-15mm, -1.699321e-16mm))
  Cylinder1_9_22_2 = Cylinder1_9_53.duplicate_mirror(point=(0mm, -8mm, 0.1mm), normal=(1mm, 1.812609e-15mm, -1.699321e-16mm))
  Cylinder1_9_23_2 = Cylinder1_9_54.duplicate_mirror(point=(0mm, -8mm, 0.1mm), normal=(1mm, 1.812609e-15mm, -1.699321e-16mm))
  Cylinder1_9_24_2 = Cylinder1_9_55.duplicate_mirror(point=(0mm, -8mm, 0.1mm), normal=(1mm, 1.812609e-15mm, -1.699321e-16mm))
  Cylinder1_9_25_2 = Cylinder1_9_56.duplicate_mirror(point=(0mm, -8mm, 0.1mm), normal=(1mm, 1.812609e-15mm, -1.699321e-16mm))
  Cylinder1_9_26_2 = Cylinder1_9_57.duplicate_mirror(point=(0mm, -8mm, 0.1mm), normal=(1mm, 1.812609e-15mm, -1.699321e-16mm))
  Cylinder1_9_27_2 = Cylinder1_9_58.duplicate_mirror(point=(0mm, -8mm, 0.1mm), normal=(1mm, 1.812609e-15mm, -1.699321e-16mm))
  Cylinder1_9_28_2 = Cylinder1_9_59.duplicate_mirror(point=(0mm, -8mm, 0.1mm), normal=(1mm, 1.812609e-15mm, -1.699321e-16mm))
  Cylinder1_9_29_2 = Cylinder1_9_60.duplicate_mirror(point=(0mm, -8mm, 0.1mm), normal=(1mm, 1.812609e-15mm, -1.699321e-16mm))
  Cylinder1_9_30_2 = Cylinder1_9_61.duplicate_mirror(point=(0mm, -8mm, 0.1mm), normal=(1mm, 1.812609e-15mm, -1.699321e-16mm))
  Cylinder1_9_31_2 = Cylinder1_9_62.duplicate_mirror(point=(0mm, -8mm, 0.1mm), normal=(1mm, 1.812609e-15mm, -1.699321e-16mm))
  Cylinder1_20 = Cylinder2.duplicate_mirror(point=(0mm, 0mm, 0mm), normal=(1mm, 0mm, 0mm))
  Polyline11 = polyline(z=gap/2, xy: (Wx/2, -Lt) (Wx/2, -Lt-Lm) (-Wx/2, -Lt-Lm) (-Wx/2, -Lt) (-Wx/2, 0mm) (Wx/2, 0mm) (Wx/2, -Lt), closed, covered)
  Polyline11.thicken(35um)
  Polyline11_1 = Polyline11.duplicate_around_axis(axis=Y, angle=180deg, total=2)
  Polyline15 = polyline(x=a/2, yz: (-Lt-2*p, gap/2) (-Lt-2*p, -gap/2) (-Lt-Lm, -gap/2) (-Lt-Lm, gap/2) (-Lt-2*p, gap/2), closed, covered)
  Polyline15.thicken(35um, both sides)
  Polyline15_1 = Polyline15.duplicate_mirror(point=(0mm, 0mm, 0mm), normal=(1mm, 0mm, 0mm))
  Polyline14 = polyline(z=gap/2, xy: (-Xs-S1, -Lt-Lm) (-Xs-S1, -Lt) (-Xy, 0mm) (-Xy +dy, 0mm) (-Xs, -Lt) (-Xs, -Lt-Lm) (-Xs-S1, -Lt-Lm), closed, covered)
  Polyline14_1 = Polyline14.duplicate_mirror(point=(0mm, 0mm, 0mm), normal=(1mm, 0mm, 0mm))
  [Polyline14, Polyline14_1].thicken(1000um, both sides)
  Cylinder2.subtract(Polyline14, Polyline14_1)
  Polyline15_1.unite(Polyline15, Cylinder2)
  Polyline16 = polyline((5mm, 13.5*p+Ln, gap/2-35um) (0.26774032mm, 14.45209mm, 0.727mm) (-0.28129714mm, 7.2188429mm, 0.727mm), AngularArc from point 0 over 3 centre=(var, 10mm, gap/2-35um) angle=angell plane=XY)
  Polyline17 = polyline((5mm, 5mm, gap/2-35um) (5mm, 13.5*p+Ln, gap/2-35um))
  Polyline16.connect(Polyline17)
  Polyline16.thicken(35um)
  Polyline16_1 = Polyline16.duplicate_around_axis(axis=Y, angle=180deg, total=2)
  Rectangle7.unite(Rectangle7_1, Rectangle8, Rectangle8_1, Rectangle9, Rectangle9_1, Cylinder1_1_2, Cylinder1_2_2, Cylinder1_3_2, Cylinder1_4_2, Cylinder1_5_2, Cylinder1_6_2, Cylinder1_7_2, Cylinder1_8_2, Cylinder1_9_2_2, Cylinder1_9_3_2, Cylinder1_9_4_2, Cylinder1_9_5_2, Cylinder1_9_6_2, Cylinder1_9_7_2, Cylinder1_9_8_2, Cylinder1_9_9_2, Cylinder1_9_10_2, Cylinder1_9_11_2, Cylinder1_9_12_2, Cylinder1_9_13_2, Cylinder1_9_14_2, Cylinder1_9_15_2, Cylinder1_9_16_2, Cylinder1_9_17_2, Cylinder1_9_18_2, Cylinder1_9_19_2, Cylinder1_9_20_2, Cylinder1_9_21_2, Cylinder1_9_22_2, Cylinder1_9_23_2, Cylinder1_9_24_2, Cylinder1_9_25_2, Cylinder1_9_26_2, Cylinder1_9_27_2, Cylinder1_9_28_2, Cylinder1_9_29_2, Cylinder1_9_30_2, Cylinder1_9_31_2, Cylinder1_9_32..Cylinder1_9_62, Cylinder1_11..Cylinder1_20, Polyline11, Polyline11_1, Polyline15_1, Polyline16, Polyline16_1)
  Box2 [Rogers RO4003 (tm)] = box(corner=(-Wx/2, -Lt-Lm, -gap/2), size=(Wx, Lt+Lm+13.5*p+Ln, gap))
  Polyline8 = polyline((6.3mm, 13.3mm, gap/2) (6.3mm, 25.2mm, gap/2))
  Polyline9 = polyline((3mm, 22mm, gap/2) (0.71984318mm, 17.609432mm, 0.762mm) (0.12169287mm, 12.698382mm, 0.762mm), AngularArc from point 0 over 3 centre=(14mm, 13.5mm, gap/2) angle=41deg plane=XY)
  Polyline8.connect(Polyline9)
  Polyline8.thicken(35um)
  Polyline8_2 = Polyline8.copy()
  Box2.subtract(Polyline8_2)
  Polyline8.delete()
  coordinate_system RelativeCS4 = origin=(a/2, -Lt, 0mm) x=(1mm, 0mm, 0mm) y=(0mm, 1mm, 0mm)
  Cylinder1 = cylinder(axis=Z, base_centre=(a/2, -Lt, -gap/1.9), radius=0.15mm, height=2*gap/1.9)
  Cylinder1_1, Cylinder1_2 = Cylinder1.duplicate_along_line(step=(0mm, -p, 0mm), total=3)
  Cylinder1_3..Cylinder1_9 = Cylinder1.duplicate_along_line(step=(0mm, p, 0mm), total=8) in RelativeCS4
  Cylinder1_10 = Cylinder1.duplicate_mirror(point=(0mm, 0mm, 0mm), normal=(1mm, 0mm, 0mm))
  Cylinder1_1_1 = Cylinder1_1.duplicate_mirror(point=(0mm, 0mm, 0mm), normal=(1mm, 0mm, 0mm))
  Cylinder1_2_1 = Cylinder1_2.duplicate_mirror(point=(0mm, 0mm, 0mm), normal=(1mm, 0mm, 0mm))
  Cylinder1_3.rotate(axis=Z, angle=beta) in RelativeCS4
  Cylinder1_3_1 = Cylinder1_3.duplicate_mirror(point=(0mm, 0mm, 0mm), normal=(1mm, 0mm, 0mm))
  Cylinder1_4.rotate(axis=Z, angle=beta) in RelativeCS4
  Cylinder1_4_1 = Cylinder1_4.duplicate_mirror(point=(0mm, 0mm, 0mm), normal=(1mm, 0mm, 0mm))
  Cylinder1_5.rotate(axis=Z, angle=beta) in RelativeCS4
  Cylinder1_5_1 = Cylinder1_5.duplicate_mirror(point=(0mm, 0mm, 0mm), normal=(1mm, 0mm, 0mm))
  Cylinder1_6.rotate(axis=Z, angle=beta) in RelativeCS4
  Cylinder1_6_1 = Cylinder1_6.duplicate_mirror(point=(0mm, 0mm, 0mm), normal=(1mm, 0mm, 0mm))
  Cylinder1_7.rotate(axis=Z, angle=beta) in RelativeCS4
  Cylinder1_7_1 = Cylinder1_7.duplicate_mirror(point=(0mm, 0mm, 0mm), normal=(1mm, 0mm, 0mm))
  Cylinder1_8.rotate(axis=Z, angle=beta) in RelativeCS4
  Cylinder1_8_1 = Cylinder1_8.duplicate_mirror(point=(0mm, 0mm, 0mm), normal=(1mm, 0mm, 0mm))
  Cylinder1_9.rotate(axis=Z, angle=beta) in RelativeCS4
  Cylinder1_9_1 = Cylinder1_9.duplicate_mirror(point=(0mm, 0mm, 0mm), normal=(1mm, 0mm, 0mm))
  Cylinder1_9_2..Cylinder1_9_31 = Cylinder1_9.duplicate_along_line(step=(0mm, p, 0mm), total=31)
  Cylinder1_9_10_1 = Cylinder1_9_10.duplicate_mirror(point=(0mm, -8mm, 0.1mm), normal=(1mm, 1.812609e-15mm, -1.699321e-16mm))
  Cylinder1_9_11_1 = Cylinder1_9_11.duplicate_mirror(point=(0mm, -8mm, 0.1mm), normal=(1mm, 1.812609e-15mm, -1.699321e-16mm))
  Cylinder1_9_12_1 = Cylinder1_9_12.duplicate_mirror(point=(0mm, -8mm, 0.1mm), normal=(1mm, 1.812609e-15mm, -1.699321e-16mm))
  Cylinder1_9_13_1 = Cylinder1_9_13.duplicate_mirror(point=(0mm, -8mm, 0.1mm), normal=(1mm, 1.812609e-15mm, -1.699321e-16mm))
  Cylinder1_9_14_1 = Cylinder1_9_14.duplicate_mirror(point=(0mm, -8mm, 0.1mm), normal=(1mm, 1.812609e-15mm, -1.699321e-16mm))
  Cylinder1_9_15_1 = Cylinder1_9_15.duplicate_mirror(point=(0mm, -8mm, 0.1mm), normal=(1mm, 1.812609e-15mm, -1.699321e-16mm))
  Cylinder1_9_16_1 = Cylinder1_9_16.duplicate_mirror(point=(0mm, -8mm, 0.1mm), normal=(1mm, 1.812609e-15mm, -1.699321e-16mm))
  Cylinder1_9_17_1 = Cylinder1_9_17.duplicate_mirror(point=(0mm, -8mm, 0.1mm), normal=(1mm, 1.812609e-15mm, -1.699321e-16mm))
  Cylinder1_9_18_1 = Cylinder1_9_18.duplicate_mirror(point=(0mm, -8mm, 0.1mm), normal=(1mm, 1.812609e-15mm, -1.699321e-16mm))
  Cylinder1_9_19_1 = Cylinder1_9_19.duplicate_mirror(point=(0mm, -8mm, 0.1mm), normal=(1mm, 1.812609e-15mm, -1.699321e-16mm))
  Cylinder1_9_2_1 = Cylinder1_9_2.duplicate_mirror(point=(0mm, -8mm, 0.1mm), normal=(1mm, 1.812609e-15mm, -1.699321e-16mm))
  Cylinder1_9_20_1 = Cylinder1_9_20.duplicate_mirror(point=(0mm, -8mm, 0.1mm), normal=(1mm, 1.812609e-15mm, -1.699321e-16mm))
  Cylinder1_9_21_1 = Cylinder1_9_21.duplicate_mirror(point=(0mm, -8mm, 0.1mm), normal=(1mm, 1.812609e-15mm, -1.699321e-16mm))
  Cylinder1_9_22_1 = Cylinder1_9_22.duplicate_mirror(point=(0mm, -8mm, 0.1mm), normal=(1mm, 1.812609e-15mm, -1.699321e-16mm))
  Cylinder1_9_23_1 = Cylinder1_9_23.duplicate_mirror(point=(0mm, -8mm, 0.1mm), normal=(1mm, 1.812609e-15mm, -1.699321e-16mm))
  Cylinder1_9_24_1 = Cylinder1_9_24.duplicate_mirror(point=(0mm, -8mm, 0.1mm), normal=(1mm, 1.812609e-15mm, -1.699321e-16mm))
  Cylinder1_9_25_1 = Cylinder1_9_25.duplicate_mirror(point=(0mm, -8mm, 0.1mm), normal=(1mm, 1.812609e-15mm, -1.699321e-16mm))
  Cylinder1_9_26_1 = Cylinder1_9_26.duplicate_mirror(point=(0mm, -8mm, 0.1mm), normal=(1mm, 1.812609e-15mm, -1.699321e-16mm))
  Cylinder1_9_27_1 = Cylinder1_9_27.duplicate_mirror(point=(0mm, -8mm, 0.1mm), normal=(1mm, 1.812609e-15mm, -1.699321e-16mm))
  Cylinder1_9_28_1 = Cylinder1_9_28.duplicate_mirror(point=(0mm, -8mm, 0.1mm), normal=(1mm, 1.812609e-15mm, -1.699321e-16mm))
  Cylinder1_9_29_1 = Cylinder1_9_29.duplicate_mirror(point=(0mm, -8mm, 0.1mm), normal=(1mm, 1.812609e-15mm, -1.699321e-16mm))
  Cylinder1_9_3_1 = Cylinder1_9_3.duplicate_mirror(point=(0mm, -8mm, 0.1mm), normal=(1mm, 1.812609e-15mm, -1.699321e-16mm))
  Cylinder1_9_30_1 = Cylinder1_9_30.duplicate_mirror(point=(0mm, -8mm, 0.1mm), normal=(1mm, 1.812609e-15mm, -1.699321e-16mm))
  Cylinder1_9_31_1 = Cylinder1_9_31.duplicate_mirror(point=(0mm, -8mm, 0.1mm), normal=(1mm, 1.812609e-15mm, -1.699321e-16mm))
  Cylinder1_9_4_1 = Cylinder1_9_4.duplicate_mirror(point=(0mm, -8mm, 0.1mm), normal=(1mm, 1.812609e-15mm, -1.699321e-16mm))
  Cylinder1_9_5_1 = Cylinder1_9_5.duplicate_mirror(point=(0mm, -8mm, 0.1mm), normal=(1mm, 1.812609e-15mm, -1.699321e-16mm))
  Cylinder1_9_6_1 = Cylinder1_9_6.duplicate_mirror(point=(0mm, -8mm, 0.1mm), normal=(1mm, 1.812609e-15mm, -1.699321e-16mm))
  Cylinder1_9_7_1 = Cylinder1_9_7.duplicate_mirror(point=(0mm, -8mm, 0.1mm), normal=(1mm, 1.812609e-15mm, -1.699321e-16mm))
  Cylinder1_9_8_1 = Cylinder1_9_8.duplicate_mirror(point=(0mm, -8mm, 0.1mm), normal=(1mm, 1.812609e-15mm, -1.699321e-16mm))
  Cylinder1_9_9_1 = Cylinder1_9_9.duplicate_mirror(point=(0mm, -8mm, 0.1mm), normal=(1mm, 1.812609e-15mm, -1.699321e-16mm))
  Box2.subtract(Cylinder1, Cylinder1_1, Cylinder1_1_1, Cylinder1_10, Cylinder1_2, Cylinder1_2_1, Cylinder1_3, Cylinder1_3_1, Cylinder1_4, Cylinder1_4_1, Cylinder1_5, Cylinder1_5_1, Cylinder1_6, Cylinder1_6_1, Cylinder1_7, Cylinder1_7_1, Cylinder1_8, Cylinder1_8_1, Cylinder1_9, Cylinder1_9_1, Cylinder1_9_10, Cylinder1_9_10_1, Cylinder1_9_11, Cylinder1_9_11_1, Cylinder1_9_12, Cylinder1_9_12_1, Cylinder1_9_13, Cylinder1_9_13_1, Cylinder1_9_14, Cylinder1_9_14_1, Cylinder1_9_15, Cylinder1_9_15_1, Cylinder1_9_16, Cylinder1_9_16_1, Cylinder1_9_17, Cylinder1_9_17_1, Cylinder1_9_18, Cylinder1_9_18_1, Cylinder1_9_19, Cylinder1_9_19_1, Cylinder1_9_2, Cylinder1_9_2_1, Cylinder1_9_20, Cylinder1_9_20_1, Cylinder1_9_21, Cylinder1_9_21_1, Cylinder1_9_22, Cylinder1_9_22_1, Cylinder1_9_23, Cylinder1_9_23_1, Cylinder1_9_24, Cylinder1_9_24_1, Cylinder1_9_25, Cylinder1_9_25_1, Cylinder1_9_26, Cylinder1_9_26_1, Cylinder1_9_27, Cylinder1_9_27_1, Cylinder1_9_28, Cylinder1_9_28_1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)
  Cylinder3 = cylinder(axis=Z, base_centre=(a/2, -Lt, -gap/1.9), radius=0.15mm, height=2*gap/1.9)
  Cylinder2_1 = Cylinder3.copy()
  Box2.subtract(Cylinder2_1)
  Polyline19 = polyline(x=a/2, yz: (-Lt-2*p, gap/2) (-Lt-2*p, -gap/2) (-Lt-Lm, -gap/2) (-Lt-Lm, gap/2) (-Lt-2*p, gap/2), closed, covered)
  Polyline19.thicken(35um, both sides)
  Polyline15_2 = Polyline19.duplicate_mirror(point=(0mm, 0mm, 0mm), normal=(1mm, 0mm, 0mm))
  Polyline18 = polyline(z=gap/2, xy: (-Xs-S1, -Lt-Lm) (-Xs-S1, -Lt) (-Xy, 0mm) (-Xy +dy, 0mm) (-Xs, -Lt) (-Xs, -Lt-Lm) (-Xs-S1, -Lt-Lm), closed, covered)
  Polyline14_2 = Polyline18.duplicate_mirror(point=(0mm, 0mm, 0mm), normal=(1mm, 0mm, 0mm))
  [Polyline18, Polyline14_2].thicken(1000um, both sides)
  Cylinder3.subtract(Polyline18, Polyline14_2)
  Polyline15_2.unite(Polyline19, Cylinder3)
  Polyline15_1_1 = Polyline15_2.copy()
  Box2.subtract(Polyline15_1_1)
  Polyline15_2.delete()
  Rectangle7_2 = Rectangle7.copy()
  Box2.subtract(Rectangle7_2)
  Polyline20 = polyline(z=gap/2, xy: (-Xs-S1, -Lt-Lm) (-Xs-S1, -Lt) (-Xy, 0.1mm) (-Xy +dy, 0.1mm) (-Xs, -Lt) (-Xs, -Lt-Lm) (-Xs-S1, -Lt-Lm), closed, covered)
  Polyline20.thicken(1000um, both sides)
  Polyline20_1 = Polyline20.duplicate_mirror(point=(0mm, 0mm, 0mm), normal=(1mm, 0mm, 0mm))
  Rectangle7.subtract(Polyline20, Polyline20_1)
boundaries and excitations:
  Rad1: Radiation Objects=Box6
  1: Lumped Port Objects=Rectangle3 Modes{Mode1{IntLine{middle of Rectangle3.edge(z at corner) -> middle of Rectangle3.edge(z opposite corner)} CharImp=Zpi RenormImp=50ohm}} Impedance=50ohm
setups:
  Setup1: HfssDriven Frequency=10GHz MaxDeltaS=0.02 MaximumPasses=6 MinimumPasses=1 MinimumConvergedPasses=1 PercentRefinement=30 BasisOrder=1 PortAccuracy=2
    sweep Sweep: 7GHz to 13GHz step 0.1GHz; Type=Discrete SaveFields SaveRadFields
source amplitudes:
  1:1: 1W 0deg
radiation setups:
  Infinite Sphere1: Infinite Sphere Theta=-180deg..180deg step 10deg Phi=0deg..360deg step 10deg
field plots:
  Vector_Jsurf1: Jsurf over Rectangle7.face(all 440) on Setup1 : LastAdaptive at Freq=10GHz Phase=0deg
reports:
  XY Plot 4: VSWR(1) vs Freq on Setup1 : Sweep [Xs=all]
  XY Plot 6: dB(S(1,1)) vs Freq on Setup1 : Sweep [Xs=all]; markers m1 at 8.5GHz
  XY Plot 8: dB(RealizedGainTotal) vs Freq on Setup1 : Sweep, Infinite Sphere1 [Theta=90deg Phi=90deg dy=3mm]
  Radiation Pattern 1: dB(RealizedGainTotal) vs Theta on Setup1 : Sweep, Infinite Sphere1 [Phi=90deg Freq=10.2GHz]; markers m1 at 90deg
  3D Polar Plot 1: dB(GainTotal) vs Phi, Theta on Setup1 : Sweep, Infinite Sphere1 [Freq=10GHz]
