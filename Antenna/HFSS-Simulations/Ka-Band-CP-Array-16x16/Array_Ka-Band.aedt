# Ansys Electronics Desktop project, version 2020.2
materials:
  Foam: permittivity=1.05 dielectric_loss_tangent=0.004
  Rogers RO4003 (tm): permittivity=3.55 dielectric_loss_tangent=0.0027
  Teflon (tm): permittivity=2.1 dielectric_loss_tangent=0.001
  copper: permeability=0.999991 conductivity=58000000
  vacuum: permittivity=1

design Single-Element-Ka1 (HFSS, DrivenModal, model units mm)
variables:
  wy = 1.02mm
  Port_loc = -2.7mm
  xd = 11mm
  h = 0.5mm
  xu = 4.1mm
  yu = 4.1mm
  H_Foam = 0.5mm
  Wx_up = 0.6mm
  L = 4.6mm
  W = 4.6mm
  wp = 0.9mm
  Lp = 0.7mm
  Wx = 0.8mm
  Scalevariation = 0.5mm
  SC_V = 1
  SC_SMA = 0.16
  d = 0mm
  Lcore = 11mm
geometry:
  Down_Sub [Rogers RO4003 (tm)] = box(corner=(-xd/2, -xd/2, 0mm), size=(xd, xd, h))
  Patch_up [copper] = rectangle(corner=(-xu/2, -yu/2, 2*h+H_Foam+0.035mm), x_size=xu, y_size=yu)
  Patch_up.thicken(0.035mm)
  Polyline2 = polyline(z=2*h+H_Foam, xy: (-xu/2, Wx_up) (-Wx_up, yu/2) (-xu/2, yu/2) (-xu/2, Wx_up), covered)
  Polyline2.thicken(1mm, both sides)
  Polyline2_1 = Polyline2.duplicate_around_axis(axis=Z, angle=180deg, total=2)
  Patch_up.subtract(Polyline2, Polyline2_1)
  Up_Sub [Rogers RO4003 (tm)] = box(corner=(-xd/2, -xd/2, h+H_Foam+0.035mm), size=(xd, xd, h))
  Patch_down_1 = rectangle(corner=(-L/2, -wp/2, h), x_size=-Lp, y_size=wp)
  Patch_down_1.thicken(-0.035mm)
  Rectangle2_1 = Patch_down_1.duplicate_around_axis(axis=Z, angle=270deg, total=2)
  Patch_down_1_1 = Patch_down_1.copy()
  Foam [Foam] = box(corner=(-xd/2, -xd/2, h+0.035mm), size=(xd, xd, H_Foam))
  Foam.subtract(Patch_down_1_1)
  Patch = rectangle(corner=(-L/2, -W/2, h), x_size=L, y_size=W)
  Patch.thicken(0.035mm)
  Ground [copper] = rectangle(corner=(-xd/2, -xd/2, 0mm), x_size=xd, y_size=xd)
  Ground.thicken(-0.035mm)
  Polyline1 = polyline(z=h, xy: (-Wx, W/2) (-L/2, Wx) (-L/2, W/2) (-Wx, W/2), closed, covered)
  Polyline1.thicken(1mm, both sides)
  Polyline1_1 = Polyline1.duplicate_around_axis(axis=Z, angle=180deg, total=2)
  [Down_Sub, Patch_up, Up_Sub, Patch_down_1, Foam].scale(SC_V, SC_V, SC_V)
  Rectangle2_1.unite(Patch, Patch_down_1)
  Connector1_Shield1 = imported_body(D:\Energy Harvesting\HFSS\SMA-KHD135-1.sat)
  Connector1_Shield1.rotate(axis=Y, angle=-90deg)
  Cylinder23 = cylinder(axis=Z, base_centre=(0mm, 0mm, 14.5mm), radius=2.05mm, height=-12.5mm)
  Cylinder24 = cylinder(axis=Z, base_centre=(0mm, 0mm, 16.5mm), radius=0.65mm, height=-14.5mm)
  Cylinder23.subtract(Cylinder24)
  Connector1_Shield1.subtract(Cylinder23)
  Connector1_Shield1.move(5mm, 8.5mm, (-16.5+1) mm)
  Cylinder29 = cylinder(axis=Z, base_centre=(5mm, 8.5mm, 1mm), radius=0.65mm, height=-14.5mm)
  Connector1_Shield1.subtract(Cylinder29)
  Connector1_Shield1.move(0mm, 0mm, (4-4+0.965) mm)
  Connector1_Shield1.rotate(axis=Y, angle=180deg)
  Connector1_Shield1.rotate(axis=Z, angle=180deg)
  Connector1_Shield1.move(0mm, 17mm, 0.965mm)
  Connector1_Shield1.move(0mm, 0mm, d)
  Connector1_Shield1.move(-5mm, -8.5mm, 0.035mm)
  Connector1_Shield1.move(-0.05mm, 0mm, -6.035mm)
  Connector1_Shield1.rotate(axis=Y, angle=180deg)
  Connector1_Shield1.scale(SC_SMA, SC_SMA, SC_SMA)
  Connector1_Core1 = cylinder(axis=Z, base_centre=(5mm, 8.5mm, 13.5mm+d), radius=0.65mm, height=-Lcore)
  Cylinder34 = cylinder(axis=Z, base_centre=(0mm, 0mm, 37.705mm), radius=0.65mm, height=-5mm)
  Connector1_Core1.subtract(Cylinder34)
  Connector1_Core1.move(-5mm, -8.5mm, 0.035mm)
  Connector1_Core1.move(-0.05mm, 0mm, -6.035mm)
  Connector1_Core1.rotate(axis=Y, angle=180deg)
  Connector1_Core1.scale(SC_SMA, SC_SMA, SC_SMA)
  Teflon1 [Teflon (tm)] = cylinder(axis=Z, base_centre=(5mm, 8.5mm, 13.5mm+d), radius=2.05mm, height=-7.5mm)
  Cylinder33 = cylinder(axis=Z, base_centre=(5mm, 8.5mm, 13.5mm+d), radius=0.65mm, height=-13.535mm)
  Teflon1.subtract(Cylinder33)
  Teflon1.move(-5mm, -8.5mm, 0.035mm)
  Teflon1.move(-0.05mm, 0mm, -6.035mm)
  Teflon1.rotate(axis=Y, angle=180deg)
  Teflon1.scale(SC_SMA, SC_SMA, SC_SMA)
  [Teflon1, Connector1_Core1, Connector1_Shield1].move(Port_loc, 0mm, -0.035mm)
  Teflon2 = cylinder(axis=Z, base_centre=(5mm, 8.5mm, 13.5mm+d), radius=2.05mm, height=-9mm)
  Teflon2.move(-5mm, -8.5mm, 0.035mm)
  Teflon2.move(-0.05mm, 0mm, -6.035mm)
  Teflon2.rotate(axis=Y, angle=180deg)
  Teflon2.scale(SC_SMA, SC_SMA, SC_SMA)
  Teflon2.move(Port_loc, 0mm, -0.035mm)
  Teflon2_1 = Teflon2.duplicate_around_axis(axis=Z, angle=-90deg, total=2)
  Teflon1_1 [Teflon (tm)] = Teflon1.duplicate_around_axis(axis=Z, angle=-90deg, total=2)
  Connector1_Shield1_1 = Connector1_Shield1.duplicate_around_axis(axis=Z, angle=-90deg, total=2)
  Connector1_Core1_1 [copper] = Connector1_Core1.duplicate_around_axis(axis=Z, angle=-90deg, total=2)
  Ground.subtract(Teflon2, Teflon2_1)
  Connector1_Core1_1.unite(Connector1_Core1, Rectangle2_1)
  Connector1_Core1_1_1 = Connector1_Core1_1.copy()
  Down_Sub.subtract(Connector1_Core1_1_1)
  Ground.unite(Connector1_Shield1_1, Connector1_Shield1)
  Connector1_Core1_1.subtract(Polyline1, Polyline1_1)
  RadiatingSurface [vacuum] = region(absolute_offset: +X=0mm, -X=0mm, +Y=0mm, -Y=0mm, +Z=5.4054054mm, -Z=2mm)
boundaries and excitations:
  Open1: Radiation Objects=RadiatingSurface
  1: Lumped Port Faces=Teflon1_1.face(4 of 4) Modes{Mode1{IntLine{Teflon1_1.vertex(2 of 4) -> Teflon1_1.vertex(4 of 4)} CharImp=Zpi RenormImp=50ohm}} Impedance=50ohm
  2: Lumped Port Faces=Teflon1.face(3 of 3) Modes{Mode1{IntLine{Teflon1.edge(#12019) at -0.25 along -> Teflon1.edge(2 of 2) at 0.25 along} CharImp=Zpi RenormImp=50ohm}} Impedance=50ohm
setups:
  Setup1: HfssDriven Frequency=18.5GHz MaxDeltaS=0.02 MaximumPasses=7 MinimumPasses=1 MinimumConvergedPasses=1 PercentRefinement=30 BasisOrder=-1 PortAccuracy=2 IterativeResidual=1e-06 DDMSolverResidual=0.0001 SaveRadFieldsOnly
    sweep Sweep: 16GHz to 21GHz, 300 points; Type=Interpolating SaveFields SaveRadFields InterpTolerance=0.5 InterpMaxSolns=250 InterpUsePortImped=false PassivityErrorTolerance=0.0001
source amplitudes:
  1:1: 1W 0deg
  2:1: 0W 0deg
radiation setups:
  3D: Infinite Sphere Theta=-180deg..180deg step 1deg Phi=-180deg..180deg step 1deg
  Elevation: Infinite Sphere Theta=-180deg..180deg step 1deg Phi=0deg..90deg step 90deg
  Azimuth: Infinite Sphere Theta=90deg..90deg step 0deg Phi=-180deg..180deg step 1deg
  antenna array: RegularArray NumUCells=16 NumVCells=16 CellUDist=11mm CellVDist=11mm UDirnX=1 UDirnY=0 UDirnZ=0 VDirnX=0 VDirnY=1 VDirnZ=0 FirstCellPosX=0mm FirstCellPosY=0mm FirstCellPosZ=0mm Behavior=UseScanAngle ScanAnglePhi=0deg ScanAngleTheta=0deg UDirnPhaseShift=0deg VDirnPhaseShift=0deg
reports:
  S Parameter Plot 2: dB(S(1,1)) vs Freq on Setup1 : Sweep; markers MX1 at x=1.7920566e+10
  Gain Plot 1: dB(GainTotal) vs Phi, Theta on Setup1 : LastAdaptive, 3D [Freq=18.5GHz]
  Gain Plot 2: dB(GainTotal) vs Theta on Setup1 : LastAdaptive, 3D [Phi=90deg Freq=18.5GHz]; markers MX1 at x=1.0412233, MX2 at x=0.82549357
  Axial Ratio Plot 1: dB(AxialRatioValue) vs Theta on Setup1 : Sweep, 3D [Phi=0deg Freq=all]
  Axial Ratio Plot 2: dB(AxialRatioValue) vs Freq on Setup1 : Sweep, 3D [Theta=0deg Phi=0deg]

design Single-Element-Ka2 (HFSS, DrivenModal, model units mm)
variables:
  wy = 1.02mm
  Port_loc = -2.7mm
  xd = 11mm
  h = 0.5mm
  xu = 4.1mm
  yu = 4.1mm
  H_Foam = 0.5mm
  Wx_up = 0.6mm
  L = 4.6mm
  W = 4.6mm
  wp = 0.9mm
  Lp = 0.7mm
  Wx = 0.8mm
  Scalevariation = 0.5mm
  SC_V = 1
  SC_SMA = 0.16
  d = 0mm
  Lcore = 11mm
geometry:
  Down_Sub [Rogers RO4003 (tm)] = box(corner=(-xd/2, -xd/2, 0mm), size=(xd, xd, h))
  Patch_up [copper] = rectangle(corner=(-xu/2, -yu/2, 2*h+H_Foam+0.035mm), x_size=xu, y_size=yu)
  Patch_up.thicken(0.035mm)
  Polyline2 = polyline(z=2*h+H_Foam, xy: (-xu/2, Wx_up) (-Wx_up, yu/2) (-xu/2, yu/2) (-xu/2, Wx_up), covered)
  Polyline2.thicken(1mm, both sides)
  Polyline2_1 = Polyline2.duplicate_around_axis(axis=Z, angle=180deg, total=2)
  Patch_up.subtract(Polyline2, Polyline2_1)
  Up_Sub [Rogers RO4003 (tm)] = box(corner=(-xd/2, -xd/2, h+H_Foam+0.035mm), size=(xd, xd, h))
  Patch_down_1 = rectangle(corner=(-L/2, -wp/2, h), x_size=-Lp, y_size=wp)
  Patch_down_1.thicken(-0.035mm)
  Patch_Down [copper] = Patch_down_1.duplicate_around_axis(axis=Z, angle=270deg, total=2)
  Patch_down_1_1 = Patch_down_1.copy()
  Foam [Foam] = box(corner=(-xd/2, -xd/2, h+0.035mm), size=(xd, xd, H_Foam))
  Foam.subtract(Patch_down_1_1)
  Patch = rectangle(corner=(-L/2, -W/2, h), x_size=L, y_size=W)
  Patch.thicken(0.035mm)
  Ground [copper] = rectangle(corner=(-xd/2, -xd/2, 0mm), x_size=xd, y_size=xd)
  Ground.thicken(-0.035mm)
  Polyline1 = polyline(z=h, xy: (-Wx, W/2) (-L/2, Wx) (-L/2, W/2) (-Wx, W/2), closed, covered)
  Polyline1.thicken(1mm, both sides)
  Polyline1_1 = Polyline1.duplicate_around_axis(axis=Z, angle=180deg, total=2)
  [Down_Sub, Patch_up, Up_Sub, Patch_down_1, Foam].scale(SC_V, SC_V, SC_V)
  Patch_Down.unite(Patch, Patch_down_1)
  Connector1_Shield1 = imported_body(D:\Energy Harvesting\HFSS\SMA-KHD135-1.sat)
  Connector1_Shield1.rotate(axis=Y, angle=-90deg)
  Cylinder23 = cylinder(axis=Z, base_centre=(0mm, 0mm, 14.5mm), radius=2.05mm, height=-12.5mm)
  Cylinder24 = cylinder(axis=Z, base_centre=(0mm, 0mm, 16.5mm), radius=0.65mm, height=-14.5mm)
  Cylinder23.subtract(Cylinder24)
  Connector1_Shield1.subtract(Cylinder23)
  Connector1_Shield1.move(5mm, 8.5mm, (-16.5+1) mm)
  Cylinder29 = cylinder(axis=Z, base_centre=(5mm, 8.5mm, 1mm), radius=0.65mm, height=-14.5mm)
  Connector1_Shield1.subtract(Cylinder29)
  Connector1_Shield1.move(0mm, 0mm, (4-4+0.965) mm)
  Connector1_Shield1.rotate(axis=Y, angle=180deg)
  Connector1_Shield1.rotate(axis=Z, angle=180deg)
  Connector1_Shield1.move(0mm, 17mm, 0.965mm)
  Connector1_Shield1.move(0mm, 0mm, d)
  Connector1_Shield1.move(-5mm, -8.5mm, 0.035mm)
  Connector1_Shield1.move(-0.05mm, 0mm, -6.035mm)
  Connector1_Shield1.rotate(axis=Y, angle=180deg)
  Connector1_Shield1.scale(SC_SMA, SC_SMA, SC_SMA)
  Connector1_Core1 = cylinder(axis=Z, base_centre=(5mm, 8.5mm, 13.5mm+d), radius=0.65mm, height=-Lcore)
  Cylinder34 = cylinder(axis=Z, base_centre=(0mm, 0mm, 37.705mm), radius=0.65mm, height=-5mm)
  Connector1_Core1.subtract(Cylinder34)
  Connector1_Core1.move(-5mm, -8.5mm, 0.035mm)
  Connector1_Core1.move(-0.05mm, 0mm, -6.035mm)
  Connector1_Core1.rotate(axis=Y, angle=180deg)
  Connector1_Core1.scale(SC_SMA, SC_SMA, SC_SMA)
  Teflon1 [Teflon (tm)] = cylinder(axis=Z, base_centre=(5mm, 8.5mm, 13.5mm+d), radius=2.05mm, height=-7.5mm)
  Cylinder33 = cylinder(axis=Z, base_centre=(5mm, 8.5mm, 13.5mm+d), radius=0.65mm, height=-13.535mm)
  Teflon1.subtract(Cylinder33)
  Teflon1.move(-5mm, -8.5mm, 0.035mm)
  Teflon1.move(-0.05mm, 0mm, -6.035mm)
  Teflon1.rotate(axis=Y, angle=180deg)
  Teflon1.scale(SC_SMA, SC_SMA, SC_SMA)
  [Teflon1, Connector1_Core1, Connector1_Shield1].move(Port_loc, 0mm, -0.035mm)
  Teflon2 = cylinder(axis=Z, base_centre=(5mm, 8.5mm, 13.5mm+d), radius=2.05mm, height=-9mm)
  Teflon2.move(-5mm, -8.5mm, 0.035mm)
  Teflon2.move(-0.05mm, 0mm, -6.035mm)
  Teflon2.rotate(axis=Y, angle=180deg)
  Teflon2.scale(SC_SMA, SC_SMA, SC_SMA)
  Teflon2.move(Port_loc, 0mm, -0.035mm)
  Teflon2_1 = Teflon2.duplicate_around_axis(axis=Z, angle=-90deg, total=2)
  Teflon1_1 [Teflon (tm)] = Teflon1.duplicate_around_axis(axis=Z, angle=-90deg, total=2)
  Connector1_Shield1_1 = Connector1_Shield1.duplicate_around_axis(axis=Z, angle=-90deg, total=2)
  Connector1_Core1_1 = Connector1_Core1.duplicate_around_axis(axis=Z, angle=-90deg, total=2)
  Patch_Down.subtract(Polyline1, Polyline1_1)
  [Teflon1, Teflon1_1, Patch_up, Connector1_Core1_1, Connector1_Core1, Connector1_Shield1, Connector1_Shield1_1, Patch_Down, Teflon2, Teflon2_1].rotate(axis=Z, angle=-45deg)
  Ground.subtract(Teflon2, Teflon2_1)
  Ground.unite(Connector1_Shield1_1, Connector1_Shield1)
  Patch_Down.unite(Connector1_Core1_1, Connector1_Core1)
  Patch_Down_2 = Patch_Down.copy()
  Down_Sub.subtract(Patch_Down_2)
  RadiatingSurface [vacuum] = region(absolute_offset=5.4054054mm on all sides)
boundaries and excitations:
  Open1: Radiation Objects=RadiatingSurface
  1: Lumped Port Faces=Teflon1_1.face(4 of 4) Modes{Mode1{IntLine{Teflon1_1.vertex(2 of 4) -> Teflon1_1.vertex(4 of 4)} CharImp=Zpi RenormImp=50ohm}} Impedance=50ohm
  2: Lumped Port Faces=Teflon1.face(3 of 3) Modes{Mode1{IntLine{Teflon1.edge(#12019) at -0.25 along -> Teflon1.edge(2 of 2) at 0.25 along} CharImp=Zpi RenormImp=50ohm}} Impedance=50ohm
setups:
  Setup1: HfssDriven MultipleAdaptiveFreqsSetup{AdaptAt{Frequency=16GHz Delta=0.02} AdaptAt{Frequency=17GHz Delta=0.02} AdaptAt{Frequency=17.5GHz Delta=0.02} AdaptAt{Frequency=18GHz Delta=0.02} AdaptAt{Frequency=18.5GHz Delta=0.02} AdaptAt{Frequency=19GHz Delta=0.02} AdaptAt{Frequency=20GHz Delta=0.02} AdaptAt{Frequency=21GHz Delta=0.02}} MaximumPasses=7 MinimumPasses=1 MinimumConvergedPasses=1 PercentRefinement=30 BasisOrder=-1 PortAccuracy=2 IterativeResidual=1e-06 DDMSolverResidual=0.0001 SaveRadFieldsOnly
    sweep Sweep: 16GHz to 21GHz, 300 points; Type=Interpolating SaveFields SaveRadFields InterpTolerance=0.5 InterpMaxSolns=250 InterpUsePortImped=false PassivityErrorTolerance=0.0001
source amplitudes:
  1:1: 1W 0deg
  2:1: 0W 0deg
radiation setups:
  3D: Infinite Sphere Theta=-180deg..180deg step 2deg Phi=-180deg..180deg step 2deg
  Elevation: Infinite Sphere Theta=-180deg..180deg step 1deg Phi=0deg..90deg step 90deg
  Azimuth: Infinite Sphere Theta=90deg..90deg step 0deg Phi=-180deg..180deg step 1deg
reports:
  S Parameter Plot 2: dB(S(1,1)) vs Freq on Setup1 : Sweep
  Gain Plot 1: dB(GainTotal) vs Phi, Theta on Setup1 : LastAdaptive, 3D [Freq=18.5GHz]
  Axial Ratio Plot 1: dB(AxialRatioValue) vs Freq on Setup1 : LastAdaptive, 3D [Theta=0deg Phi=0deg]
  Axial Ratio Plot 2: dB(AxialRatioValue) vs Freq on Setup1 : LastAdaptive, 3D [Theta=0deg Phi=0deg]
  Axial Ratio Plot 3: dB(AxialRatioValue) vs Theta on Setup1 : LastAdaptive, 3D [Phi=90deg Freq=17GHz,18GHz,18.5GHz,19GHz,20GHz]; markers MX1 at x=0.0017900813
  Gain Plot 2: dB(GainTotal) vs Theta on Setup1 : LastAdaptive, 3D [Phi=0deg,90deg Freq=18.5GHz]
  Gain Plot 3: dB(GainLHCP), dB(GainRHCP) vs Theta on Setup1 : LastAdaptive, 3D [Phi=0deg,90deg Freq=18.5GHz]; markers MX1 at x=0.013444595
  Gain Plot 4: dB(GainTotal) vs Freq on Setup1 : LastAdaptive, 3D [Theta=0deg Phi=0deg]

design Ka-Array16.16 (HFSS, DrivenModal, model units mm)
variables:
  wy = 1.02mm
  Port_loc = -2.7mm
  xd = 11mm
  h = 0.5mm
  xu = 4.1mm
  yu = 4.1mm
  H_Foam = 0.5mm
  Wx_up = 0.6mm
  L = 4.6mm
  W = 4.6mm
  wp = 0.9mm
  Lp = 0.7mm
  Wx = 0.8mm
  Scalevariation = 0.5mm
  SC_V = 1
  SC_SMA = 0.16
  d = 0mm
  Lcore = 11mm
  ScanFrequency = 18500000000Hz
  ScanAngleTheta = 0deg
  ScanAnglePhi = 0deg
  ScanPhaseShiftA = -((ScanFrequency*0.0*sin(ScanAngleTheta)*cos(ScanAnglePhi)) + (ScanFrequency*2.30542952415e-10*sin(ScanAngleTheta)*sin(ScanAnglePhi))) rad
  ScanPhaseShiftB = -((ScanFrequency*2.30542952415e-10*sin(ScanAngleTheta)*cos(ScanAnglePhi)) + (ScanFrequency*0.0*sin(ScanAngleTheta)*sin(ScanAnglePhi))) rad
  ScanMag1 = 0W
  ScanPhase1 = 0deg
  ScanMag2 = 1W
  ScanPhase2 = 0deg
geometry:
  Down_Sub [Rogers RO4003 (tm)] = box(corner=(-xd/2, -xd/2, 0mm), size=(xd, xd, h))
  Patch_up [copper] = rectangle(corner=(-xu/2, -yu/2, 2*h+H_Foam+0.035mm), x_size=xu, y_size=yu)
  Patch_up.thicken(0.035mm)
  Polyline2 = polyline(z=2*h+H_Foam, xy: (-xu/2, Wx_up) (-Wx_up, yu/2) (-xu/2, yu/2) (-xu/2, Wx_up), covered)
  Polyline2.thicken(1mm, both sides)
  Polyline2_1 = Polyline2.duplicate_around_axis(axis=Z, angle=180deg, total=2)
  Patch_up.subtract(Polyline2, Polyline2_1)
  Up_Sub [Rogers RO4003 (tm)] = box(corner=(-xd/2, -xd/2, h+H_Foam+0.035mm), size=(xd, xd, h))
  Patch_down_1 = rectangle(corner=(-L/2, -wp/2, h), x_size=-Lp, y_size=wp)
  Patch_down_1.thicken(-0.035mm)
  Patch_Down [copper] = Patch_down_1.duplicate_around_axis(axis=Z, angle=270deg, total=2)
  Patch_down_1_1 = Patch_down_1.copy()
  Foam [Foam] = box(corner=(-xd/2, -xd/2, h+0.035mm), size=(xd, xd, H_Foam))
  Foam.subtract(Patch_down_1_1)
  Patch = rectangle(corner=(-L/2, -W/2, h), x_size=L, y_size=W)
  Patch.thicken(0.035mm)
  Ground [copper] = rectangle(corner=(-xd/2, -xd/2, 0mm), x_size=xd, y_size=xd)
  Ground.thicken(-0.035mm)
  Polyline1 = polyline(z=h, xy: (-Wx, W/2) (-L/2, Wx) (-L/2, W/2) (-Wx, W/2), closed, covered)
  Polyline1.thicken(1mm, both sides)
  Polyline1_1 = Polyline1.duplicate_around_axis(axis=Z, angle=180deg, total=2)
  [Down_Sub, Patch_up, Up_Sub, Patch_down_1, Foam].scale(SC_V, SC_V, SC_V)
  Patch_Down.unite(Patch, Patch_down_1)
  Connector1_Shield1 = imported_body(D:\Energy Harvesting\HFSS\SMA-KHD135-1.sat)
  Connector1_Shield1.rotate(axis=Y, angle=-90deg)
  Cylinder23 = cylinder(axis=Z, base_centre=(0mm, 0mm, 14.5mm), radius=2.05mm, height=-12.5mm)
  Cylinder24 = cylinder(axis=Z, base_centre=(0mm, 0mm, 16.5mm), radius=0.65mm, height=-14.5mm)
  Cylinder23.subtract(Cylinder24)
  Connector1_Shield1.subtract(Cylinder23)
  Connector1_Shield1.move(5mm, 8.5mm, (-16.5+1) mm)
  Cylinder29 = cylinder(axis=Z, base_centre=(5mm, 8.5mm, 1mm), radius=0.65mm, height=-14.5mm)
  Connector1_Shield1.subtract(Cylinder29)
  Connector1_Shield1.move(0mm, 0mm, (4-4+0.965) mm)
  Connector1_Shield1.rotate(axis=Y, angle=180deg)
  Connector1_Shield1.rotate(axis=Z, angle=180deg)
  Connector1_Shield1.move(0mm, 17mm, 0.965mm)
  Connector1_Shield1.move(0mm, 0mm, d)
  Connector1_Shield1.move(-5mm, -8.5mm, 0.035mm)
  Connector1_Shield1.move(-0.05mm, 0mm, -6.035mm)
  Connector1_Shield1.rotate(axis=Y, angle=180deg)
  Connector1_Shield1.scale(SC_SMA, SC_SMA, SC_SMA)
  Connector1_Core1 = cylinder(axis=Z, base_centre=(5mm, 8.5mm, 13.5mm+d), radius=0.65mm, height=-Lcore)
  Cylinder34 = cylinder(axis=Z, base_centre=(0mm, 0mm, 37.705mm), radius=0.65mm, height=-5mm)
  Connector1_Core1.subtract(Cylinder34)
  Connector1_Core1.move(-5mm, -8.5mm, 0.035mm)
  Connector1_Core1.move(-0.05mm, 0mm, -6.035mm)
  Connector1_Core1.rotate(axis=Y, angle=180deg)
  Connector1_Core1.scale(SC_SMA, SC_SMA, SC_SMA)
  Teflon1 [Teflon (tm)] = cylinder(axis=Z, base_centre=(5mm, 8.5mm, 13.5mm+d), radius=2.05mm, height=-7.5mm)
  Cylinder33 = cylinder(axis=Z, base_centre=(5mm, 8.5mm, 13.5mm+d), radius=0.65mm, height=-13.535mm)
  Teflon1.subtract(Cylinder33)
  Teflon1.move(-5mm, -8.5mm, 0.035mm)
  Teflon1.move(-0.05mm, 0mm, -6.035mm)
  Teflon1.rotate(axis=Y, angle=180deg)
  Teflon1.scale(SC_SMA, SC_SMA, SC_SMA)
  [Teflon1, Connector1_Core1, Connector1_Shield1].move(Port_loc, 0mm, -0.035mm)
  Teflon2 = cylinder(axis=Z, base_centre=(5mm, 8.5mm, 13.5mm+d), radius=2.05mm, height=-9mm)
  Teflon2.move(-5mm, -8.5mm, 0.035mm)
  Teflon2.move(-0.05mm, 0mm, -6.035mm)
  Teflon2.rotate(axis=Y, angle=180deg)
  Teflon2.scale(SC_SMA, SC_SMA, SC_SMA)
  Teflon2.move(Port_loc, 0mm, -0.035mm)
  Teflon2_1 = Teflon2.duplicate_around_axis(axis=Z, angle=-90deg, total=2)
  Teflon1_1 [Teflon (tm)] = Teflon1.duplicate_around_axis(axis=Z, angle=-90deg, total=2)
  Connector1_Shield1_1 = Connector1_Shield1.duplicate_around_axis(axis=Z, angle=-90deg, total=2)
  Connector1_Core1_1 = Connector1_Core1.duplicate_around_axis(axis=Z, angle=-90deg, total=2)
  Patch_Down.subtract(Polyline1, Polyline1_1)
  [Teflon1, Teflon1_1, Patch_up, Connector1_Core1_1, Connector1_Core1, Connector1_Shield1, Connector1_Shield1_1, Patch_Down, Teflon2, Teflon2_1].rotate(axis=Z, angle=-45deg)
  Ground.subtract(Teflon2, Teflon2_1)
  Ground.unite(Connector1_Shield1_1, Connector1_Shield1)
  Patch_Down.unite(Connector1_Core1_1, Connector1_Core1)
  Patch_Down_2 = Patch_Down.copy()
  Down_Sub.subtract(Patch_Down_2)
  RadiatingSurface [vacuum] = region(absolute_offset: +X=0mm, -X=0mm, +Y=0mm, -Y=0mm, +Z=5.4054054mm, -Z=1mm)
boundaries and excitations:
  LatticePair1: Lattice Pair Faces=RadiatingSurface.face(-y, +y) CoordSysVector{RadiatingSurface.vertex(4 of 8) -> RadiatingSurface.vertex(7 of 8)} ReverseV PhaseDelay=UseScanAngle Phi=0deg Theta=0deg
  LatticePair2: Lattice Pair Faces=RadiatingSurface.face(-x, +x) CoordSysVector{RadiatingSurface.vertex(3 of 8) -> RadiatingSurface.vertex(8 of 8)} ReverseV PhaseDelay=UseScanAngle Phi=0deg Theta=0deg
  Rad1: Radiation Faces=RadiatingSurface.face(+z, -z)
  1: Lumped Port Faces=Teflon1_1.face(4 of 4) Modes{Mode1{IntLine{Teflon1_1.vertex(2 of 4) -> Teflon1_1.vertex(4 of 4)} CharImp=Zpi RenormImp=50ohm}} Impedance=50ohm
  2: Lumped Port Faces=Teflon1.face(3 of 3) Modes{Mode1{IntLine{Teflon1.edge(#12019) at -0.25 along -> Teflon1.edge(2 of 2) at 0.25 along} CharImp=Zpi RenormImp=50ohm}} Impedance=50ohm
array:
  Type=Regular Name=A UseAirObjects RowMasterBnd=LatticePair1 ColumnMasterBnd=LatticePair2 RowDimension=16 ColumnDimension=16 RenderType=0 Padding=1 PostProcessRow=8 PostProcessCol=8
setups:
  Setup1: HfssDriven Frequency=18.5GHz MaxDeltaS=0.02 MaximumPasses=6 MinimumPasses=1 MinimumConvergedPasses=1 PercentRefinement=30 BasisOrder=-1 PortAccuracy=2 UseDomains DDMSolverResidual=0.0001 SaveRadFieldsOnly
    sweep Sweep: 16GHz to 21GHz, 400 points; Type=Interpolating SaveFields SaveRadFields InterpTolerance=0.5 InterpMaxSolns=250 InterpUsePortImped=false PassivityErrorTolerance=0.0001
source amplitudes:
  1:1: ScanMag1 ScanPhase1 + (0*ScanPhaseShiftA + 0*ScanPhaseShiftB)
  1:2: ScanMag1 ScanPhase1 + (0*ScanPhaseShiftA + 1*ScanPhaseShiftB)
  1:3: ScanMag1 ScanPhase1 + (0*ScanPhaseShiftA + 2*ScanPhaseShiftB)
  1:4: ScanMag1 ScanPhase1 + (0*ScanPhaseShiftA + 3*ScanPhaseShiftB)
  1:5: ScanMag1 ScanPhase1 + (0*ScanPhaseShiftA + 4*ScanPhaseShiftB)
  1:6: ScanMag1 ScanPhase1 + (0*ScanPhaseShiftA + 5*ScanPhaseShiftB)
  1:7: ScanMag1 ScanPhase1 + (0*ScanPhaseShiftA + 6*ScanPhaseShiftB)
  1:8: ScanMag1 ScanPhase1 + (0*ScanPhaseShiftA + 7*ScanPhaseShiftB)
  1:9: ScanMag1 ScanPhase1 + (0*ScanPhaseShiftA + 8*ScanPhaseShiftB)
  1:10: ScanMag1 ScanPhase1 + (0*ScanPhaseShiftA + 9*ScanPhaseShiftB)
  1:11: ScanMag1 ScanPhase1 + (0*ScanPhaseShiftA + 10*ScanPhaseShiftB)
  1:12: ScanMag1 ScanPhase1 + (0*ScanPhaseShiftA + 11*ScanPhaseShiftB)
  1:13: ScanMag1 ScanPhase1 + (0*ScanPhaseShiftA + 12*ScanPhaseShiftB)
  1:14: ScanMag1 ScanPhase1 + (0*ScanPhaseShiftA + 13*ScanPhaseShiftB)
  1:15: ScanMag1 ScanPhase1 + (0*ScanPhaseShiftA + 14*ScanPhaseShiftB)
  1:16: ScanMag1 ScanPhase1 + (0*ScanPhaseShiftA + 15*ScanPhaseShiftB)
  1:17: ScanMag1 ScanPhase1 + (1*ScanPhaseShiftA + 0*ScanPhaseShiftB)
  1:18: ScanMag1 ScanPhase1 + (1*ScanPhaseShiftA + 1*ScanPhaseShiftB)
  1:19: ScanMag1 ScanPhase1 + (1*ScanPhaseShiftA + 2*ScanPhaseShiftB)
  1:20: ScanMag1 ScanPhase1 + (1*ScanPhaseShiftA + 3*ScanPhaseShiftB)
  1:21: ScanMag1 ScanPhase1 + (1*ScanPhaseShiftA + 4*ScanPhaseShiftB)
  1:22: ScanMag1 ScanPhase1 + (1*ScanPhaseShiftA + 5*ScanPhaseShiftB)
  1:23: ScanMag1 ScanPhase1 + (1*ScanPhaseShiftA + 6*ScanPhaseShiftB)
  1:24: ScanMag1 ScanPhase1 + (1*ScanPhaseShiftA + 7*ScanPhaseShiftB)
  1:25: ScanMag1 ScanPhase1 + (1*ScanPhaseShiftA + 8*ScanPhaseShiftB)
  1:26: ScanMag1 ScanPhase1 + (1*ScanPhaseShiftA + 9*ScanPhaseShiftB)
  1:27: ScanMag1 ScanPhase1 + (1*ScanPhaseShiftA + 10*ScanPhaseShiftB)
  1:28: ScanMag1 ScanPhase1 + (1*ScanPhaseShiftA + 11*ScanPhaseShiftB)
  1:29: ScanMag1 ScanPhase1 + (1*ScanPhaseShiftA + 12*ScanPhaseShiftB)
  1:30: ScanMag1 ScanPhase1 + (1*ScanPhaseShiftA + 13*ScanPhaseShiftB)
  1:31: ScanMag1 ScanPhase1 + (1*ScanPhaseShiftA + 14*ScanPhaseShiftB)
  1:32: ScanMag1 ScanPhase1 + (1*ScanPhaseShiftA + 15*ScanPhaseShiftB)
  1:33: ScanMag1 ScanPhase1 + (2*ScanPhaseShiftA + 0*ScanPhaseShiftB)
  1:34: ScanMag1 ScanPhase1 + (2*ScanPhaseShiftA + 1*ScanPhaseShiftB)
  1:35: ScanMag1 ScanPhase1 + (2*ScanPhaseShiftA + 2*ScanPhaseShiftB)
  1:36: ScanMag1 ScanPhase1 + (2*ScanPhaseShiftA + 3*ScanPhaseShiftB)
  1:37: ScanMag1 ScanPhase1 + (2*ScanPhaseShiftA + 4*ScanPhaseShiftB)
  1:38: ScanMag1 ScanPhase1 + (2*ScanPhaseShiftA + 5*ScanPhaseShiftB)
  1:39: ScanMag1 ScanPhase1 + (2*ScanPhaseShiftA + 6*ScanPhaseShiftB)
  1:40: ScanMag1 ScanPhase1 + (2*ScanPhaseShiftA + 7*ScanPhaseShiftB)
  1:41: ScanMag1 ScanPhase1 + (2*ScanPhaseShiftA + 8*ScanPhaseShiftB)
  1:42: ScanMag1 ScanPhase1 + (2*ScanPhaseShiftA + 9*ScanPhaseShiftB)
  1:43: ScanMag1 ScanPhase1 + (2*ScanPhaseShiftA + 10*ScanPhaseShiftB)
  1:44: ScanMag1 ScanPhase1 + (2*ScanPhaseShiftA + 11*ScanPhaseShiftB)
  1:45: ScanMag1 ScanPhase1 + (2*ScanPhaseShiftA + 12*ScanPhaseShiftB)
  1:46: ScanMag1 ScanPhase1 + (2*ScanPhaseShiftA + 13*ScanPhaseShiftB)
  1:47: ScanMag1 ScanPhase1 + (2*ScanPhaseShiftA + 14*ScanPhaseShiftB)
  1:48: ScanMag1 ScanPhase1 + (2*ScanPhaseShiftA + 15*ScanPhaseShiftB)
  1:49: ScanMag1 ScanPhase1 + (3*ScanPhaseShiftA + 0*ScanPhaseShiftB)
  1:50: ScanMag1 ScanPhase1 + (3*ScanPhaseShiftA + 1*ScanPhaseShiftB)
  1:51: ScanMag1 ScanPhase1 + (3*ScanPhaseShiftA + 2*ScanPhaseShiftB)
  1:52: ScanMag1 ScanPhase1 + (3*ScanPhaseShiftA + 3*ScanPhaseShiftB)
  1:53: ScanMag1 ScanPhase1 + (3*ScanPhaseShiftA + 4*ScanPhaseShiftB)
  1:54: ScanMag1 ScanPhase1 + (3*ScanPhaseShiftA + 5*ScanPhaseShiftB)
  1:55: ScanMag1 ScanPhase1 + (3*ScanPhaseShiftA + 6*ScanPhaseShiftB)
  1:56: ScanMag1 ScanPhase1 + (3*ScanPhaseShiftA + 7*ScanPhaseShiftB)
  1:57: ScanMag1 ScanPhase1 + (3*ScanPhaseShiftA + 8*ScanPhaseShiftB)
  1:58: ScanMag1 ScanPhase1 + (3*ScanPhaseShiftA + 9*ScanPhaseShiftB)
  1:59: ScanMag1 ScanPhase1 + (3*ScanPhaseShiftA + 10*ScanPhaseShiftB)
  1:60: ScanMag1 ScanPhase1 + (3*ScanPhaseShiftA + 11*ScanPhaseShiftB)
  1:61: ScanMag1 ScanPhase1 + (3*ScanPhaseShiftA + 12*ScanPhaseShiftB)
  1:62: ScanMag1 ScanPhase1 + (3*ScanPhaseShiftA + 13*ScanPhaseShiftB)
  1:63: ScanMag1 ScanPhase1 + (3*ScanPhaseShiftA + 14*ScanPhaseShiftB)
  1:64: ScanMag1 ScanPhase1 + (3*ScanPhaseShiftA + 15*ScanPhaseShiftB)
  1:65: ScanMag1 ScanPhase1 + (4*ScanPhaseShiftA + 0*ScanPhaseShiftB)
  1:66: ScanMag1 ScanPhase1 + (4*ScanPhaseShiftA + 1*ScanPhaseShiftB)
  1:67: ScanMag1 ScanPhase1 + (4*ScanPhaseShiftA + 2*ScanPhaseShiftB)
  1:68: ScanMag1 ScanPhase1 + (4*ScanPhaseShiftA + 3*ScanPhaseShiftB)
  1:69: ScanMag1 ScanPhase1 + (4*ScanPhaseShiftA + 4*ScanPhaseShiftB)
  1:70: ScanMag1 ScanPhase1 + (4*ScanPhaseShiftA + 5*ScanPhaseShiftB)
  1:71: ScanMag1 ScanPhase1 + (4*ScanPhaseShiftA + 6*ScanPhaseShiftB)
  1:72: ScanMag1 ScanPhase1 + (4*ScanPhaseShiftA + 7*ScanPhaseShiftB)
  1:73: ScanMag1 ScanPhase1 + (4*ScanPhaseShiftA + 8*ScanPhaseShiftB)
  1:74: ScanMag1 ScanPhase1 + (4*ScanPhaseShiftA + 9*ScanPhaseShiftB)
  1:75: ScanMag1 ScanPhase1 + (4*ScanPhaseShiftA + 10*ScanPhaseShiftB)
  1:76: ScanMag1 ScanPhase1 + (4*ScanPhaseShiftA + 11*ScanPhaseShiftB)
  1:77: ScanMag1 ScanPhase1 + (4*ScanPhaseShiftA + 12*ScanPhaseShiftB)
  1:78: ScanMag1 ScanPhase1 + (4*ScanPhaseShiftA + 13*ScanPhaseShiftB)
  1:79: ScanMag1 ScanPhase1 + (4*ScanPhaseShiftA + 14*ScanPhaseShiftB)
  1:80: ScanMag1 ScanPhase1 + (4*ScanPhaseShiftA + 15*ScanPhaseShiftB)
  1:81: ScanMag1 ScanPhase1 + (5*ScanPhaseShiftA + 0*ScanPhaseShiftB)
  1:82: ScanMag1 ScanPhase1 + (5*ScanPhaseShiftA + 1*ScanPhaseShiftB)
  1:83: ScanMag1 ScanPhase1 + (5*ScanPhaseShiftA + 2*ScanPhaseShiftB)
  1:84: ScanMag1 ScanPhase1 + (5*ScanPhaseShiftA + 3*ScanPhaseShiftB)
  1:85: ScanMag1 ScanPhase1 + (5*ScanPhaseShiftA + 4*ScanPhaseShiftB)
  1:86: ScanMag1 ScanPhase1 + (5*ScanPhaseShiftA + 5*ScanPhaseShiftB)
  1:87: ScanMag1 ScanPhase1 + (5*ScanPhaseShiftA + 6*ScanPhaseShiftB)
  1:88: ScanMag1 ScanPhase1 + (5*ScanPhaseShiftA + 7*ScanPhaseShiftB)
  1:89: ScanMag1 ScanPhase1 + (5*ScanPhaseShiftA + 8*ScanPhaseShiftB)
  1:90: ScanMag1 ScanPhase1 + (5*ScanPhaseShiftA + 9*ScanPhaseShiftB)
  1:91: ScanMag1 ScanPhase1 + (5*ScanPhaseShiftA + 10*ScanPhaseShiftB)
  1:92: ScanMag1 ScanPhase1 + (5*ScanPhaseShiftA + 11*ScanPhaseShiftB)
  1:93: ScanMag1 ScanPhase1 + (5*ScanPhaseShiftA + 12*ScanPhaseShiftB)
  1:94: ScanMag1 ScanPhase1 + (5*ScanPhaseShiftA + 13*ScanPhaseShiftB)
  1:95: ScanMag1 ScanPhase1 + (5*ScanPhaseShiftA + 14*ScanPhaseShiftB)
  1:96: ScanMag1 ScanPhase1 + (5*ScanPhaseShiftA + 15*ScanPhaseShiftB)
  1:97: ScanMag1 ScanPhase1 + (6*ScanPhaseShiftA + 0*ScanPhaseShiftB)
  1:98: ScanMag1 ScanPhase1 + (6*ScanPhaseShiftA + 1*ScanPhaseShiftB)
  1:99: ScanMag1 ScanPhase1 + (6*ScanPhaseShiftA + 2*ScanPhaseShiftB)
  1:100: ScanMag1 ScanPhase1 + (6*ScanPhaseShiftA + 3*ScanPhaseShiftB)
  1:101: ScanMag1 ScanPhase1 + (6*ScanPhaseShiftA + 4*ScanPhaseShiftB)
  1:102: ScanMag1 ScanPhase1 + (6*ScanPhaseShiftA + 5*ScanPhaseShiftB)
  1:103: ScanMag1 ScanPhase1 + (6*ScanPhaseShiftA + 6*ScanPhaseShiftB)
  1:104: ScanMag1 ScanPhase1 + (6*ScanPhaseShiftA + 7*ScanPhaseShiftB)
  1:105: ScanMag1 ScanPhase1 + (6*ScanPhaseShiftA + 8*ScanPhaseShiftB)
  1:106: ScanMag1 ScanPhase1 + (6*ScanPhaseShiftA + 9*ScanPhaseShiftB)
  1:107: ScanMag1 ScanPhase1 + (6*ScanPhaseShiftA + 10*ScanPhaseShiftB)
  1:108: ScanMag1 ScanPhase1 + (6*ScanPhaseShiftA + 11*ScanPhaseShiftB)
  1:109: ScanMag1 ScanPhase1 + (6*ScanPhaseShiftA + 12*ScanPhaseShiftB)
  1:110: ScanMag1 ScanPhase1 + (6*ScanPhaseShiftA + 13*ScanPhaseShiftB)
  1:111: ScanMag1 ScanPhase1 + (6*ScanPhaseShiftA + 14*ScanPhaseShiftB)
  1:112: ScanMag1 ScanPhase1 + (6*ScanPhaseShiftA + 15*ScanPhaseShiftB)
  1:113: ScanMag1 ScanPhase1 + (7*ScanPhaseShiftA + 0*ScanPhaseShiftB)
  1:114: ScanMag1 ScanPhase1 + (7*ScanPhaseShiftA + 1*ScanPhaseShiftB)
  1:115: ScanMag1 ScanPhase1 + (7*ScanPhaseShiftA + 2*ScanPhaseShiftB)
  1:116: ScanMag1 ScanPhase1 + (7*ScanPhaseShiftA + 3*ScanPhaseShiftB)
  1:117: ScanMag1 ScanPhase1 + (7*ScanPhaseShiftA + 4*ScanPhaseShiftB)
  1:118: ScanMag1 ScanPhase1 + (7*ScanPhaseShiftA + 5*ScanPhaseShiftB)
  1:119: ScanMag1 ScanPhase1 + (7*ScanPhaseShiftA + 6*ScanPhaseShiftB)
  1:120: ScanMag1 ScanPhase1 + (7*ScanPhaseShiftA + 7*ScanPhaseShiftB)
  1:121: ScanMag1 ScanPhase1 + (7*ScanPhaseShiftA + 8*ScanPhaseShiftB)
  1:122: ScanMag1 ScanPhase1 + (7*ScanPhaseShiftA + 9*ScanPhaseShiftB)
  1:123: ScanMag1 ScanPhase1 + (7*ScanPhaseShiftA + 10*ScanPhaseShiftB)
  1:124: ScanMag1 ScanPhase1 + (7*ScanPhaseShiftA + 11*ScanPhaseShiftB)
  1:125: ScanMag1 ScanPhase1 + (7*ScanPhaseShiftA + 12*ScanPhaseShiftB)
  1:126: ScanMag1 ScanPhase1 + (7*ScanPhaseShiftA + 13*ScanPhaseShiftB)
  1:127: ScanMag1 ScanPhase1 + (7*ScanPhaseShiftA + 14*ScanPhaseShiftB)
  1:128: ScanMag1 ScanPhase1 + (7*ScanPhaseShiftA + 15*ScanPhaseShiftB)
  1:129: ScanMag1 ScanPhase1 + (8*ScanPhaseShiftA + 0*ScanPhaseShiftB)
  1:130: ScanMag1 ScanPhase1 + (8*ScanPhaseShiftA + 1*ScanPhaseShiftB)
  1:131: ScanMag1 ScanPhase1 + (8*ScanPhaseShiftA + 2*ScanPhaseShiftB)
  1:132: ScanMag1 ScanPhase1 + (8*ScanPhaseShiftA + 3*ScanPhaseShiftB)
  1:133: ScanMag1 ScanPhase1 + (8*ScanPhaseShiftA + 4*ScanPhaseShiftB)
  1:134: ScanMag1 ScanPhase1 + (8*ScanPhaseShiftA + 5*ScanPhaseShiftB)
  1:135: ScanMag1 ScanPhase1 + (8*ScanPhaseShiftA + 6*ScanPhaseShiftB)
  1:136: ScanMag1 ScanPhase1 + (8*ScanPhaseShiftA + 7*ScanPhaseShiftB)
  1:137: ScanMag1 ScanPhase1 + (8*ScanPhaseShiftA + 8*ScanPhaseShiftB)
  1:138: ScanMag1 ScanPhase1 + (8*ScanPhaseShiftA + 9*ScanPhaseShiftB)
  1:139: ScanMag1 ScanPhase1 + (8*ScanPhaseShiftA + 10*ScanPhaseShiftB)
  1:140: ScanMag1 ScanPhase1 + (8*ScanPhaseShiftA + 11*ScanPhaseShiftB)
  1:141: ScanMag1 ScanPhase1 + (8*ScanPhaseShiftA + 12*ScanPhaseShiftB)
  1:142: ScanMag1 ScanPhase1 + (8*ScanPhaseShiftA + 13*ScanPhaseShiftB)
  1:143: ScanMag1 ScanPhase1 + (8*ScanPhaseShiftA + 14*ScanPhaseShiftB)
  1:144: ScanMag1 ScanPhase1 + (8*ScanPhaseShiftA + 15*ScanPhaseShiftB)
  1:145: ScanMag1 ScanPhase1 + (9*ScanPhaseShiftA + 0*ScanPhaseShiftB)
  1:146: ScanMag1 ScanPhase1 + (9*ScanPhaseShiftA + 1*ScanPhaseShiftB)
  1:147: ScanMag1 ScanPhase1 + (9*ScanPhaseShiftA + 2*ScanPhaseShiftB)
  1:148: ScanMag1 ScanPhase1 + (9*ScanPhaseShiftA + 3*ScanPhaseShiftB)
  1:149: ScanMag1 ScanPhase1 + (9*ScanPhaseShiftA + 4*ScanPhaseShiftB)
  1:150: ScanMag1 ScanPhase1 + (9*ScanPhaseShiftA + 5*ScanPhaseShiftB)
  1:151: ScanMag1 ScanPhase1 + (9*ScanPhaseShiftA + 6*ScanPhaseShiftB)
  1:152: ScanMag1 ScanPhase1 + (9*ScanPhaseShiftA + 7*ScanPhaseShiftB)
  1:153: ScanMag1 ScanPhase1 + (9*ScanPhaseShiftA + 8*ScanPhaseShiftB)
  1:154: ScanMag1 ScanPhase1 + (9*ScanPhaseShiftA + 9*ScanPhaseShiftB)
  1:155: ScanMag1 ScanPhase1 + (9*ScanPhaseShiftA + 10*ScanPhaseShiftB)
  1:156: ScanMag1 ScanPhase1 + (9*ScanPhaseShiftA + 11*ScanPhaseShiftB)
  1:157: ScanMag1 ScanPhase1 + (9*ScanPhaseShiftA + 12*ScanPhaseShiftB)
  1:158: ScanMag1 ScanPhase1 + (9*ScanPhaseShiftA + 13*ScanPhaseShiftB)
  1:159: ScanMag1 ScanPhase1 + (9*ScanPhaseShiftA + 14*ScanPhaseShiftB)
  1:160: ScanMag1 ScanPhase1 + (9*ScanPhaseShiftA + 15*ScanPhaseShiftB)
  1:161: ScanMag1 ScanPhase1 + (10*ScanPhaseShiftA + 0*ScanPhaseShiftB)
  1:162: ScanMag1 ScanPhase1 + (10*ScanPhaseShiftA + 1*ScanPhaseShiftB)
  1:163: ScanMag1 ScanPhase1 + (10*ScanPhaseShiftA + 2*ScanPhaseShiftB)
  1:164: ScanMag1 ScanPhase1 + (10*ScanPhaseShiftA + 3*ScanPhaseShiftB)
  1:165: ScanMag1 ScanPhase1 + (10*ScanPhaseShiftA + 4*ScanPhaseShiftB)
  1:166: ScanMag1 ScanPhase1 + (10*ScanPhaseShiftA + 5*ScanPhaseShiftB)
  1:167: ScanMag1 ScanPhase1 + (10*ScanPhaseShiftA + 6*ScanPhaseShiftB)
  1:168: ScanMag1 ScanPhase1 + (10*ScanPhaseShiftA + 7*ScanPhaseShiftB)
  1:169: ScanMag1 ScanPhase1 + (10*ScanPhaseShiftA + 8*ScanPhaseShiftB)
  1:170: ScanMag1 ScanPhase1 + (10*ScanPhaseShiftA + 9*ScanPhaseShiftB)
  1:171: ScanMag1 ScanPhase1 + (10*ScanPhaseShiftA + 10*ScanPhaseShiftB)
  1:172: ScanMag1 ScanPhase1 + (10*ScanPhaseShiftA + 11*ScanPhaseShiftB)
  1:173: ScanMag1 ScanPhase1 + (10*ScanPhaseShiftA + 12*ScanPhaseShiftB)
  1:174: ScanMag1 ScanPhase1 + (10*ScanPhaseShiftA + 13*ScanPhaseShiftB)
  1:175: ScanMag1 ScanPhase1 + (10*ScanPhaseShiftA + 14*ScanPhaseShiftB)
  1:176: ScanMag1 ScanPhase1 + (10*ScanPhaseShiftA + 15*ScanPhaseShiftB)
  1:177: ScanMag1 ScanPhase1 + (11*ScanPhaseShiftA + 0*ScanPhaseShiftB)
  1:178: ScanMag1 ScanPhase1 + (11*ScanPhaseShiftA + 1*ScanPhaseShiftB)
  1:179: ScanMag1 ScanPhase1 + (11*ScanPhaseShiftA + 2*ScanPhaseShiftB)
  1:180: ScanMag1 ScanPhase1 + (11*ScanPhaseShiftA + 3*ScanPhaseShiftB)
  1:181: ScanMag1 ScanPhase1 + (11*ScanPhaseShiftA + 4*ScanPhaseShiftB)
  1:182: ScanMag1 ScanPhase1 + (11*ScanPhaseShiftA + 5*ScanPhaseShiftB)
  1:183: ScanMag1 ScanPhase1 + (11*ScanPhaseShiftA + 6*ScanPhaseShiftB)
  1:184: ScanMag1 ScanPhase1 + (11*ScanPhaseShiftA + 7*ScanPhaseShiftB)
  1:185: ScanMag1 ScanPhase1 + (11*ScanPhaseShiftA + 8*ScanPhaseShiftB)
  1:186: ScanMag1 ScanPhase1 + (11*ScanPhaseShiftA + 9*ScanPhaseShiftB)
  1:187: ScanMag1 ScanPhase1 + (11*ScanPhaseShiftA + 10*ScanPhaseShiftB)
  1:188: ScanMag1 ScanPhase1 + (11*ScanPhaseShiftA + 11*ScanPhaseShiftB)
  1:189: ScanMag1 ScanPhase1 + (11*ScanPhaseShiftA + 12*ScanPhaseShiftB)
  1:190: ScanMag1 ScanPhase1 + (11*ScanPhaseShiftA + 13*ScanPhaseShiftB)
  1:191: ScanMag1 ScanPhase1 + (11*ScanPhaseShiftA + 14*ScanPhaseShiftB)
  1:192: ScanMag1 ScanPhase1 + (11*ScanPhaseShiftA + 15*ScanPhaseShiftB)
  1:193: ScanMag1 ScanPhase1 + (12*ScanPhaseShiftA + 0*ScanPhaseShiftB)
  1:194: ScanMag1 ScanPhase1 + (12*ScanPhaseShiftA + 1*ScanPhaseShiftB)
  1:195: ScanMag1 ScanPhase1 + (12*ScanPhaseShiftA + 2*ScanPhaseShiftB)
  1:196: ScanMag1 ScanPhase1 + (12*ScanPhaseShiftA + 3*ScanPhaseShiftB)
  1:197: ScanMag1 ScanPhase1 + (12*ScanPhaseShiftA + 4*ScanPhaseShiftB)
  1:198: ScanMag1 ScanPhase1 + (12*ScanPhaseShiftA + 5*ScanPhaseShiftB)
  1:199: ScanMag1 ScanPhase1 + (12*ScanPhaseShiftA + 6*ScanPhaseShiftB)
  1:200: ScanMag1 ScanPhase1 + (12*ScanPhaseShiftA + 7*ScanPhaseShiftB)
  1:201: ScanMag1 ScanPhase1 + (12*ScanPhaseShiftA + 8*ScanPhaseShiftB)
  1:202: ScanMag1 ScanPhase1 + (12*ScanPhaseShiftA + 9*ScanPhaseShiftB)
  1:203: ScanMag1 ScanPhase1 + (12*ScanPhaseShiftA + 10*ScanPhaseShiftB)
  1:204: ScanMag1 ScanPhase1 + (12*ScanPhaseShiftA + 11*ScanPhaseShiftB)
  1:205: ScanMag1 ScanPhase1 + (12*ScanPhaseShiftA + 12*ScanPhaseShiftB)
  1:206: ScanMag1 ScanPhase1 + (12*ScanPhaseShiftA + 13*ScanPhaseShiftB)
  1:207: ScanMag1 ScanPhase1 + (12*ScanPhaseShiftA + 14*ScanPhaseShiftB)
  1:208: ScanMag1 ScanPhase1 + (12*ScanPhaseShiftA + 15*ScanPhaseShiftB)
  1:209: ScanMag1 ScanPhase1 + (13*ScanPhaseShiftA + 0*ScanPhaseShiftB)
  1:210: ScanMag1 ScanPhase1 + (13*ScanPhaseShiftA + 1*ScanPhaseShiftB)
  1:211: ScanMag1 ScanPhase1 + (13*ScanPhaseShiftA + 2*ScanPhaseShiftB)
  1:212: ScanMag1 ScanPhase1 + (13*ScanPhaseShiftA + 3*ScanPhaseShiftB)
  1:213: ScanMag1 ScanPhase1 + (13*ScanPhaseShiftA + 4*ScanPhaseShiftB)
  1:214: ScanMag1 ScanPhase1 + (13*ScanPhaseShiftA + 5*ScanPhaseShiftB)
  1:215: ScanMag1 ScanPhase1 + (13*ScanPhaseShiftA + 6*ScanPhaseShiftB)
  1:216: ScanMag1 ScanPhase1 + (13*ScanPhaseShiftA + 7*ScanPhaseShiftB)
  1:217: ScanMag1 ScanPhase1 + (13*ScanPhaseShiftA + 8*ScanPhaseShiftB)
  1:218: ScanMag1 ScanPhase1 + (13*ScanPhaseShiftA + 9*ScanPhaseShiftB)
  1:219: ScanMag1 ScanPhase1 + (13*ScanPhaseShiftA + 10*ScanPhaseShiftB)
  1:220: ScanMag1 ScanPhase1 + (13*ScanPhaseShiftA + 11*ScanPhaseShiftB)
  1:221: ScanMag1 ScanPhase1 + (13*ScanPhaseShiftA + 12*ScanPhaseShiftB)
  1:222: ScanMag1 ScanPhase1 + (13*ScanPhaseShiftA + 13*ScanPhaseShiftB)
  1:223: ScanMag1 ScanPhase1 + (13*ScanPhaseShiftA + 14*ScanPhaseShiftB)
  1:224: ScanMag1 ScanPhase1 + (13*ScanPhaseShiftA + 15*ScanPhaseShiftB)
  1:225: ScanMag1 ScanPhase1 + (14*ScanPhaseShiftA + 0*ScanPhaseShiftB)
  1:226: ScanMag1 ScanPhase1 + (14*ScanPhaseShiftA + 1*ScanPhaseShiftB)
  1:227: ScanMag1 ScanPhase1 + (14*ScanPhaseShiftA + 2*ScanPhaseShiftB)
  1:228: ScanMag1 ScanPhase1 + (14*ScanPhaseShiftA + 3*ScanPhaseShiftB)
  1:229: ScanMag1 ScanPhase1 + (14*ScanPhaseShiftA + 4*ScanPhaseShiftB)
  1:230: ScanMag1 ScanPhase1 + (14*ScanPhaseShiftA + 5*ScanPhaseShiftB)
  1:231: ScanMag1 ScanPhase1 + (14*ScanPhaseShiftA + 6*ScanPhaseShiftB)
  1:232: ScanMag1 ScanPhase1 + (14*ScanPhaseShiftA + 7*ScanPhaseShiftB)
  1:233: ScanMag1 ScanPhase1 + (14*ScanPhaseShiftA + 8*ScanPhaseShiftB)
  1:234: ScanMag1 ScanPhase1 + (14*ScanPhaseShiftA + 9*ScanPhaseShiftB)
  1:235: ScanMag1 ScanPhase1 + (14*ScanPhaseShiftA + 10*ScanPhaseShiftB)
  1:236: ScanMag1 ScanPhase1 + (14*ScanPhaseShiftA + 11*ScanPhaseShiftB)
  1:237: ScanMag1 ScanPhase1 + (14*ScanPhaseShiftA + 12*ScanPhaseShiftB)
  1:238: ScanMag1 ScanPhase1 + (14*ScanPhaseShiftA + 13*ScanPhaseShiftB)
  1:239: ScanMag1 ScanPhase1 + (14*ScanPhaseShiftA + 14*ScanPhaseShiftB)
  1:240: ScanMag1 ScanPhase1 + (14*ScanPhaseShiftA + 15*ScanPhaseShiftB)
  1:241: ScanMag1 ScanPhase1 + (15*ScanPhaseShiftA + 0*ScanPhaseShiftB)
  1:242: ScanMag1 ScanPhase1 + (15*ScanPhaseShiftA + 1*ScanPhaseShiftB)
  1:243: ScanMag1 ScanPhase1 + (15*ScanPhaseShiftA + 2*ScanPhaseShiftB)
  1:244: ScanMag1 ScanPhase1 + (15*ScanPhaseShiftA + 3*ScanPhaseShiftB)
  1:245: ScanMag1 ScanPhase1 + (15*ScanPhaseShiftA + 4*ScanPhaseShiftB)
  1:246: ScanMag1 ScanPhase1 + (15*ScanPhaseShiftA + 5*ScanPhaseShiftB)
  1:247: ScanMag1 ScanPhase1 + (15*ScanPhaseShiftA + 6*ScanPhaseShiftB)
  1:248: ScanMag1 ScanPhase1 + (15*ScanPhaseShiftA + 7*ScanPhaseShiftB)
  1:249: ScanMag1 ScanPhase1 + (15*ScanPhaseShiftA + 8*ScanPhaseShiftB)
  1:250: ScanMag1 ScanPhase1 + (15*ScanPhaseShiftA + 9*ScanPhaseShiftB)
  1:251: ScanMag1 ScanPhase1 + (15*ScanPhaseShiftA + 10*ScanPhaseShiftB)
  1:252: ScanMag1 ScanPhase1 + (15*ScanPhaseShiftA + 11*ScanPhaseShiftB)
  1:253: ScanMag1 ScanPhase1 + (15*ScanPhaseShiftA + 12*ScanPhaseShiftB)
  1:254: ScanMag1 ScanPhase1 + (15*ScanPhaseShiftA + 13*ScanPhaseShiftB)
  1:255: ScanMag1 ScanPhase1 + (15*ScanPhaseShiftA + 14*ScanPhaseShiftB)
  1:256: ScanMag1 ScanPhase1 + (15*ScanPhaseShiftA + 15*ScanPhaseShiftB)
  2:1: ScanMag2 ScanPhase2 + (0*ScanPhaseShiftA + 0*ScanPhaseShiftB)
  2:2: ScanMag2 ScanPhase2 + (0*ScanPhaseShiftA + 1*ScanPhaseShiftB)
  2:3: ScanMag2 ScanPhase2 + (0*ScanPhaseShiftA + 2*ScanPhaseShiftB)
  2:4: ScanMag2 ScanPhase2 + (0*ScanPhaseShiftA + 3*ScanPhaseShiftB)
  2:5: ScanMag2 ScanPhase2 + (0*ScanPhaseShiftA + 4*ScanPhaseShiftB)
  2:6: ScanMag2 ScanPhase2 + (0*ScanPhaseShiftA + 5*ScanPhaseShiftB)
  2:7: ScanMag2 ScanPhase2 + (0*ScanPhaseShiftA + 6*ScanPhaseShiftB)
  2:8: ScanMag2 ScanPhase2 + (0*ScanPhaseShiftA + 7*ScanPhaseShiftB)
  2:9: ScanMag2 ScanPhase2 + (0*ScanPhaseShiftA + 8*ScanPhaseShiftB)
  2:10: ScanMag2 ScanPhase2 + (0*ScanPhaseShiftA + 9*ScanPhaseShiftB)
  2:11: ScanMag2 ScanPhase2 + (0*ScanPhaseShiftA + 10*ScanPhaseShiftB)
  2:12: ScanMag2 ScanPhase2 + (0*ScanPhaseShiftA + 11*ScanPhaseShiftB)
  2:13: ScanMag2 ScanPhase2 + (0*ScanPhaseShiftA + 12*ScanPhaseShiftB)
  2:14: ScanMag2 ScanPhase2 + (0*ScanPhaseShiftA + 13*ScanPhaseShiftB)
  2:15: ScanMag2 ScanPhase2 + (0*ScanPhaseShiftA + 14*ScanPhaseShiftB)
  2:16: ScanMag2 ScanPhase2 + (0*ScanPhaseShiftA + 15*ScanPhaseShiftB)
  2:17: ScanMag2 ScanPhase2 + (1*ScanPhaseShiftA + 0*ScanPhaseShiftB)
  2:18: ScanMag2 ScanPhase2 + (1*ScanPhaseShiftA + 1*ScanPhaseShiftB)
  2:19: ScanMag2 ScanPhase2 + (1*ScanPhaseShiftA + 2*ScanPhaseShiftB)
  2:20: ScanMag2 ScanPhase2 + (1*ScanPhaseShiftA + 3*ScanPhaseShiftB)
  2:21: ScanMag2 ScanPhase2 + (1*ScanPhaseShiftA + 4*ScanPhaseShiftB)
  2:22: ScanMag2 ScanPhase2 + (1*ScanPhaseShiftA + 5*ScanPhaseShiftB)
  2:23: ScanMag2 ScanPhase2 + (1*ScanPhaseShiftA + 6*ScanPhaseShiftB)
  2:24: ScanMag2 ScanPhase2 + (1*ScanPhaseShiftA + 7*ScanPhaseShiftB)
  2:25: ScanMag2 ScanPhase2 + (1*ScanPhaseShiftA + 8*ScanPhaseShiftB)
  2:26: ScanMag2 ScanPhase2 + (1*ScanPhaseShiftA + 9*ScanPhaseShiftB)
  2:27: ScanMag2 ScanPhase2 + (1*ScanPhaseShiftA + 10*ScanPhaseShiftB)
  2:28: ScanMag2 ScanPhase2 + (1*ScanPhaseShiftA + 11*ScanPhaseShiftB)
  2:29: ScanMag2 ScanPhase2 + (1*ScanPhaseShiftA + 12*ScanPhaseShiftB)
  2:30: ScanMag2 ScanPhase2 + (1*ScanPhaseShiftA + 13*ScanPhaseShiftB)
  2:31: ScanMag2 ScanPhase2 + (1*ScanPhaseShiftA + 14*ScanPhaseShiftB)
  2:32: ScanMag2 ScanPhase2 + (1*ScanPhaseShiftA + 15*ScanPhaseShiftB)
  2:33: ScanMag2 ScanPhase2 + (2*ScanPhaseShiftA + 0*ScanPhaseShiftB)
  2:34: ScanMag2 ScanPhase2 + (2*ScanPhaseShiftA + 1*ScanPhaseShiftB)
  2:35: ScanMag2 ScanPhase2 + (2*ScanPhaseShiftA + 2*ScanPhaseShiftB)
  2:36: ScanMag2 ScanPhase2 + (2*ScanPhaseShiftA + 3*ScanPhaseShiftB)
  2:37: ScanMag2 ScanPhase2 + (2*ScanPhaseShiftA + 4*ScanPhaseShiftB)
  2:38: ScanMag2 ScanPhase2 + (2*ScanPhaseShiftA + 5*ScanPhaseShiftB)
  2:39: ScanMag2 ScanPhase2 + (2*ScanPhaseShiftA + 6*ScanPhaseShiftB)
  2:40: ScanMag2 ScanPhase2 + (2*ScanPhaseShiftA + 7*ScanPhaseShiftB)
  2:41: ScanMag2 ScanPhase2 + (2*ScanPhaseShiftA + 8*ScanPhaseShiftB)
  2:42: ScanMag2 ScanPhase2 + (2*ScanPhaseShiftA + 9*ScanPhaseShiftB)
  2:43: ScanMag2 ScanPhase2 + (2*ScanPhaseShiftA + 10*ScanPhaseShiftB)
  2:44: ScanMag2 ScanPhase2 + (2*ScanPhaseShiftA + 11*ScanPhaseShiftB)
  2:45: ScanMag2 ScanPhase2 + (2*ScanPhaseShiftA + 12*ScanPhaseShiftB)
  2:46: ScanMag2 ScanPhase2 + (2*ScanPhaseShiftA + 13*ScanPhaseShiftB)
  2:47: ScanMag2 ScanPhase2 + (2*ScanPhaseShiftA + 14*ScanPhaseShiftB)
  2:48: ScanMag2 ScanPhase2 + (2*ScanPhaseShiftA + 15*ScanPhaseShiftB)
  2:49: ScanMag2 ScanPhase2 + (3*ScanPhaseShiftA + 0*ScanPhaseShiftB)
  2:50: ScanMag2 ScanPhase2 + (3*ScanPhaseShiftA + 1*ScanPhaseShiftB)
  2:51: ScanMag2 ScanPhase2 + (3*ScanPhaseShiftA + 2*ScanPhaseShiftB)
  2:52: ScanMag2 ScanPhase2 + (3*ScanPhaseShiftA + 3*ScanPhaseShiftB)
  2:53: ScanMag2 ScanPhase2 + (3*ScanPhaseShiftA + 4*ScanPhaseShiftB)
  2:54: ScanMag2 ScanPhase2 + (3*ScanPhaseShiftA + 5*ScanPhaseShiftB)
  2:55: ScanMag2 ScanPhase2 + (3*ScanPhaseShiftA + 6*ScanPhaseShiftB)
  2:56: ScanMag2 ScanPhase2 + (3*ScanPhaseShiftA + 7*ScanPhaseShiftB)
  2:57: ScanMag2 ScanPhase2 + (3*ScanPhaseShiftA + 8*ScanPhaseShiftB)
  2:58: ScanMag2 ScanPhase2 + (3*ScanPhaseShiftA + 9*ScanPhaseShiftB)
  2:59: ScanMag2 ScanPhase2 + (3*ScanPhaseShiftA + 10*ScanPhaseShiftB)
  2:60: ScanMag2 ScanPhase2 + (3*ScanPhaseShiftA + 11*ScanPhaseShiftB)
  2:61: ScanMag2 ScanPhase2 + (3*ScanPhaseShiftA + 12*ScanPhaseShiftB)
  2:62: ScanMag2 ScanPhase2 + (3*ScanPhaseShiftA + 13*ScanPhaseShiftB)
  2:63: ScanMag2 ScanPhase2 + (3*ScanPhaseShiftA + 14*ScanPhaseShiftB)
  2:64: ScanMag2 ScanPhase2 + (3*ScanPhaseShiftA + 15*ScanPhaseShiftB)
  2:65: ScanMag2 ScanPhase2 + (4*ScanPhaseShiftA + 0*ScanPhaseShiftB)
  2:66: ScanMag2 ScanPhase2 + (4*ScanPhaseShiftA + 1*ScanPhaseShiftB)
  2:67: ScanMag2 ScanPhase2 + (4*ScanPhaseShiftA + 2*ScanPhaseShiftB)
  2:68: ScanMag2 ScanPhase2 + (4*ScanPhaseShiftA + 3*ScanPhaseShiftB)
  2:69: ScanMag2 ScanPhase2 + (4*ScanPhaseShiftA + 4*ScanPhaseShiftB)
  2:70: ScanMag2 ScanPhase2 + (4*ScanPhaseShiftA + 5*ScanPhaseShiftB)
  2:71: ScanMag2 ScanPhase2 + (4*ScanPhaseShiftA + 6*ScanPhaseShiftB)
  2:72: ScanMag2 ScanPhase2 + (4*ScanPhaseShiftA + 7*ScanPhaseShiftB)
  2:73: ScanMag2 ScanPhase2 + (4*ScanPhaseShiftA + 8*ScanPhaseShiftB)
  2:74: ScanMag2 ScanPhase2 + (4*ScanPhaseShiftA + 9*ScanPhaseShiftB)
  2:75: ScanMag2 ScanPhase2 + (4*ScanPhaseShiftA + 10*ScanPhaseShiftB)
  2:76: ScanMag2 ScanPhase2 + (4*ScanPhaseShiftA + 11*ScanPhaseShiftB)
  2:77: ScanMag2 ScanPhase2 + (4*ScanPhaseShiftA + 12*ScanPhaseShiftB)
  2:78: ScanMag2 ScanPhase2 + (4*ScanPhaseShiftA + 13*ScanPhaseShiftB)
  2:79: ScanMag2 ScanPhase2 + (4*ScanPhaseShiftA + 14*ScanPhaseShiftB)
  2:80: ScanMag2 ScanPhase2 + (4*ScanPhaseShiftA + 15*ScanPhaseShiftB)
  2:81: ScanMag2 ScanPhase2 + (5*ScanPhaseShiftA + 0*ScanPhaseShiftB)
  2:82: ScanMag2 ScanPhase2 + (5*ScanPhaseShiftA + 1*ScanPhaseShiftB)
  2:83: ScanMag2 ScanPhase2 + (5*ScanPhaseShiftA + 2*ScanPhaseShiftB)
  2:84: ScanMag2 ScanPhase2 + (5*ScanPhaseShiftA + 3*ScanPhaseShiftB)
  2:85: ScanMag2 ScanPhase2 + (5*ScanPhaseShiftA + 4*ScanPhaseShiftB)
  2:86: ScanMag2 ScanPhase2 + (5*ScanPhaseShiftA + 5*ScanPhaseShiftB)
  2:87: ScanMag2 ScanPhase2 + (5*ScanPhaseShiftA + 6*ScanPhaseShiftB)
  2:88: ScanMag2 ScanPhase2 + (5*ScanPhaseShiftA + 7*ScanPhaseShiftB)
  2:89: ScanMag2 ScanPhase2 + (5*ScanPhaseShiftA + 8*ScanPhaseShiftB)
  2:90: ScanMag2 ScanPhase2 + (5*ScanPhaseShiftA + 9*ScanPhaseShiftB)
  2:91: ScanMag2 ScanPhase2 + (5*ScanPhaseShiftA + 10*ScanPhaseShiftB)
  2:92: ScanMag2 ScanPhase2 + (5*ScanPhaseShiftA + 11*ScanPhaseShiftB)
  2:93: ScanMag2 ScanPhase2 + (5*ScanPhaseShiftA + 12*ScanPhaseShiftB)
  2:94: ScanMag2 ScanPhase2 + (5*ScanPhaseShiftA + 13*ScanPhaseShiftB)
  2:95: ScanMag2 ScanPhase2 + (5*ScanPhaseShiftA + 14*ScanPhaseShiftB)
  2:96: ScanMag2 ScanPhase2 + (5*ScanPhaseShiftA + 15*ScanPhaseShiftB)
  2:97: ScanMag2 ScanPhase2 + (6*ScanPhaseShiftA + 0*ScanPhaseShiftB)
  2:98: ScanMag2 ScanPhase2 + (6*ScanPhaseShiftA + 1*ScanPhaseShiftB)
  2:99: ScanMag2 ScanPhase2 + (6*ScanPhaseShiftA + 2*ScanPhaseShiftB)
  2:100: ScanMag2 ScanPhase2 + (6*ScanPhaseShiftA + 3*ScanPhaseShiftB)
  2:101: ScanMag2 ScanPhase2 + (6*ScanPhaseShiftA + 4*ScanPhaseShiftB)
  2:102: ScanMag2 ScanPhase2 + (6*ScanPhaseShiftA + 5*ScanPhaseShiftB)
  2:103: ScanMag2 ScanPhase2 + (6*ScanPhaseShiftA + 6*ScanPhaseShiftB)
  2:104: ScanMag2 ScanPhase2 + (6*ScanPhaseShiftA + 7*ScanPhaseShiftB)
  2:105: ScanMag2 ScanPhase2 + (6*ScanPhaseShiftA + 8*ScanPhaseShiftB)
  2:106: ScanMag2 ScanPhase2 + (6*ScanPhaseShiftA + 9*ScanPhaseShiftB)
  2:107: ScanMag2 ScanPhase2 + (6*ScanPhaseShiftA + 10*ScanPhaseShiftB)
  2:108: ScanMag2 ScanPhase2 + (6*ScanPhaseShiftA + 11*ScanPhaseShiftB)
  2:109: ScanMag2 ScanPhase2 + (6*ScanPhaseShiftA + 12*ScanPhaseShiftB)
  2:110: ScanMag2 ScanPhase2 + (6*ScanPhaseShiftA + 13*ScanPhaseShiftB)
  2:111: ScanMag2 ScanPhase2 + (6*ScanPhaseShiftA + 14*ScanPhaseShiftB)
  2:112: ScanMag2 ScanPhase2 + (6*ScanPhaseShiftA + 15*ScanPhaseShiftB)
  2:113: ScanMag2 ScanPhase2 + (7*ScanPhaseShiftA + 0*ScanPhaseShiftB)
  2:114: ScanMag2 ScanPhase2 + (7*ScanPhaseShiftA + 1*ScanPhaseShiftB)
  2:115: ScanMag2 ScanPhase2 + (7*ScanPhaseShiftA + 2*ScanPhaseShiftB)
  2:116: ScanMag2 ScanPhase2 + (7*ScanPhaseShiftA + 3*ScanPhaseShiftB)
  2:117: ScanMag2 ScanPhase2 + (7*ScanPhaseShiftA + 4*ScanPhaseShiftB)
  2:118: ScanMag2 ScanPhase2 + (7*ScanPhaseShiftA + 5*ScanPhaseShiftB)
  2:119: ScanMag2 ScanPhase2 + (7*ScanPhaseShiftA + 6*ScanPhaseShiftB)
  2:120: ScanMag2 ScanPhase2 + (7*ScanPhaseShiftA + 7*ScanPhaseShiftB)
  2:121: ScanMag2 ScanPhase2 + (7*ScanPhaseShiftA + 8*ScanPhaseShiftB)
  2:122: ScanMag2 ScanPhase2 + (7*ScanPhaseShiftA + 9*ScanPhaseShiftB)
  2:123: ScanMag2 ScanPhase2 + (7*ScanPhaseShiftA + 10*ScanPhaseShiftB)
  2:124: ScanMag2 ScanPhase2 + (7*ScanPhaseShiftA + 11*ScanPhaseShiftB)
  2:125: ScanMag2 ScanPhase2 + (7*ScanPhaseShiftA + 12*ScanPhaseShiftB)
  2:126: ScanMag2 ScanPhase2 + (7*ScanPhaseShiftA + 13*ScanPhaseShiftB)
  2:127: ScanMag2 ScanPhase2 + (7*ScanPhaseShiftA + 14*ScanPhaseShiftB)
  2:128: ScanMag2 ScanPhase2 + (7*ScanPhaseShiftA + 15*ScanPhaseShiftB)
  2:129: ScanMag2 ScanPhase2 + (8*ScanPhaseShiftA + 0*ScanPhaseShiftB)
  2:130: ScanMag2 ScanPhase2 + (8*ScanPhaseShiftA + 1*ScanPhaseShiftB)
  2:131: ScanMag2 ScanPhase2 + (8*ScanPhaseShiftA + 2*ScanPhaseShiftB)
  2:132: ScanMag2 ScanPhase2 + (8*ScanPhaseShiftA + 3*ScanPhaseShiftB)
  2:133: ScanMag2 ScanPhase2 + (8*ScanPhaseShiftA + 4*ScanPhaseShiftB)
  2:134: ScanMag2 ScanPhase2 + (8*ScanPhaseShiftA + 5*ScanPhaseShiftB)
  2:135: ScanMag2 ScanPhase2 + (8*ScanPhaseShiftA + 6*ScanPhaseShiftB)
  2:136: ScanMag2 ScanPhase2 + (8*ScanPhaseShiftA + 7*ScanPhaseShiftB)
  2:137: ScanMag2 ScanPhase2 + (8*ScanPhaseShiftA + 8*ScanPhaseShiftB)
  2:138: ScanMag2 ScanPhase2 + (8*ScanPhaseShiftA + 9*ScanPhaseShiftB)
  2:139: ScanMag2 ScanPhase2 + (8*ScanPhaseShiftA + 10*ScanPhaseShiftB)
  2:140: ScanMag2 ScanPhase2 + (8*ScanPhaseShiftA + 11*ScanPhaseShiftB)
  2:141: ScanMag2 ScanPhase2 + (8*ScanPhaseShiftA + 12*ScanPhaseShiftB)
  2:142: ScanMag2 ScanPhase2 + (8*ScanPhaseShiftA + 13*ScanPhaseShiftB)
  2:143: ScanMag2 ScanPhase2 + (8*ScanPhaseShiftA + 14*ScanPhaseShiftB)
  2:144: ScanMag2 ScanPhase2 + (8*ScanPhaseShiftA + 15*ScanPhaseShiftB)
  2:145: ScanMag2 ScanPhase2 + (9*ScanPhaseShiftA + 0*ScanPhaseShiftB)
  2:146: ScanMag2 ScanPhase2 + (9*ScanPhaseShiftA + 1*ScanPhaseShiftB)
  2:147: ScanMag2 ScanPhase2 + (9*ScanPhaseShiftA + 2*ScanPhaseShiftB)
  2:148: ScanMag2 ScanPhase2 + (9*ScanPhaseShiftA + 3*ScanPhaseShiftB)
  2:149: ScanMag2 ScanPhase2 + (9*ScanPhaseShiftA + 4*ScanPhaseShiftB)
  2:150: ScanMag2 ScanPhase2 + (9*ScanPhaseShiftA + 5*ScanPhaseShiftB)
  2:151: ScanMag2 ScanPhase2 + (9*ScanPhaseShiftA + 6*ScanPhaseShiftB)
  2:152: ScanMag2 ScanPhase2 + (9*ScanPhaseShiftA + 7*ScanPhaseShiftB)
  2:153: ScanMag2 ScanPhase2 + (9*ScanPhaseShiftA + 8*ScanPhaseShiftB)
  2:154: ScanMag2 ScanPhase2 + (9*ScanPhaseShiftA + 9*ScanPhaseShiftB)
  2:155: ScanMag2 ScanPhase2 + (9*ScanPhaseShiftA + 10*ScanPhaseShiftB)
  2:156: ScanMag2 ScanPhase2 + (9*ScanPhaseShiftA + 11*ScanPhaseShiftB)
  2:157: ScanMag2 ScanPhase2 + (9*ScanPhaseShiftA + 12*ScanPhaseShiftB)
  2:158: ScanMag2 ScanPhase2 + (9*ScanPhaseShiftA + 13*ScanPhaseShiftB)
  2:159: ScanMag2 ScanPhase2 + (9*ScanPhaseShiftA + 14*ScanPhaseShiftB)
  2:160: ScanMag2 ScanPhase2 + (9*ScanPhaseShiftA + 15*ScanPhaseShiftB)
  2:161: ScanMag2 ScanPhase2 + (10*ScanPhaseShiftA + 0*ScanPhaseShiftB)
  2:162: ScanMag2 ScanPhase2 + (10*ScanPhaseShiftA + 1*ScanPhaseShiftB)
  2:163: ScanMag2 ScanPhase2 + (10*ScanPhaseShiftA + 2*ScanPhaseShiftB)
  2:164: ScanMag2 ScanPhase2 + (10*ScanPhaseShiftA + 3*ScanPhaseShiftB)
  2:165: ScanMag2 ScanPhase2 + (10*ScanPhaseShiftA + 4*ScanPhaseShiftB)
  2:166: ScanMag2 ScanPhase2 + (10*ScanPhaseShiftA + 5*ScanPhaseShiftB)
  2:167: ScanMag2 ScanPhase2 + (10*ScanPhaseShiftA + 6*ScanPhaseShiftB)
  2:168: ScanMag2 ScanPhase2 + (10*ScanPhaseShiftA + 7*ScanPhaseShiftB)
  2:169: ScanMag2 ScanPhase2 + (10*ScanPhaseShiftA + 8*ScanPhaseShiftB)
  2:170: ScanMag2 ScanPhase2 + (10*ScanPhaseShiftA + 9*ScanPhaseShiftB)
  2:171: ScanMag2 ScanPhase2 + (10*ScanPhaseShiftA + 10*ScanPhaseShiftB)
  2:172: ScanMag2 ScanPhase2 + (10*ScanPhaseShiftA + 11*ScanPhaseShiftB)
  2:173: ScanMag2 ScanPhase2 + (10*ScanPhaseShiftA + 12*ScanPhaseShiftB)
  2:174: ScanMag2 ScanPhase2 + (10*ScanPhaseShiftA + 13*ScanPhaseShiftB)
  2:175: ScanMag2 ScanPhase2 + (10*ScanPhaseShiftA + 14*ScanPhaseShiftB)
  2:176: ScanMag2 ScanPhase2 + (10*ScanPhaseShiftA + 15*ScanPhaseShiftB)
  2:177: ScanMag2 ScanPhase2 + (11*ScanPhaseShiftA + 0*ScanPhaseShiftB)
  2:178: ScanMag2 ScanPhase2 + (11*ScanPhaseShiftA + 1*ScanPhaseShiftB)
  2:179: ScanMag2 ScanPhase2 + (11*ScanPhaseShiftA + 2*ScanPhaseShiftB)
  2:180: ScanMag2 ScanPhase2 + (11*ScanPhaseShiftA + 3*ScanPhaseShiftB)
  2:181: ScanMag2 ScanPhase2 + (11*ScanPhaseShiftA + 4*ScanPhaseShiftB)
  2:182: ScanMag2 ScanPhase2 + (11*ScanPhaseShiftA + 5*ScanPhaseShiftB)
  2:183: ScanMag2 ScanPhase2 + (11*ScanPhaseShiftA + 6*ScanPhaseShiftB)
  2:184: ScanMag2 ScanPhase2 + (11*ScanPhaseShiftA + 7*ScanPhaseShiftB)
  2:185: ScanMag2 ScanPhase2 + (11*ScanPhaseShiftA + 8*ScanPhaseShiftB)
  2:186: ScanMag2 ScanPhase2 + (11*ScanPhaseShiftA + 9*ScanPhaseShiftB)
  2:187: ScanMag2 ScanPhase2 + (11*ScanPhaseShiftA + 10*ScanPhaseShiftB)
  2:188: ScanMag2 ScanPhase2 + (11*ScanPhaseShiftA + 11*ScanPhaseShiftB)
  2:189: ScanMag2 ScanPhase2 + (11*ScanPhaseShiftA + 12*ScanPhaseShiftB)
  2:190: ScanMag2 ScanPhase2 + (11*ScanPhaseShiftA + 13*ScanPhaseShiftB)
  2:191: ScanMag2 ScanPhase2 + (11*ScanPhaseShiftA + 14*ScanPhaseShiftB)
  2:192: ScanMag2 ScanPhase2 + (11*ScanPhaseShiftA + 15*ScanPhaseShiftB)
  2:193: ScanMag2 ScanPhase2 + (12*ScanPhaseShiftA + 0*ScanPhaseShiftB)
  2:194: ScanMag2 ScanPhase2 + (12*ScanPhaseShiftA + 1*ScanPhaseShiftB)
  2:195: ScanMag2 ScanPhase2 + (12*ScanPhaseShiftA + 2*ScanPhaseShiftB)
  2:196: ScanMag2 ScanPhase2 + (12*ScanPhaseShiftA + 3*ScanPhaseShiftB)
  2:197: ScanMag2 ScanPhase2 + (12*ScanPhaseShiftA + 4*ScanPhaseShiftB)
  2:198: ScanMag2 ScanPhase2 + (12*ScanPhaseShiftA + 5*ScanPhaseShiftB)
  2:199: ScanMag2 ScanPhase2 + (12*ScanPhaseShiftA + 6*ScanPhaseShiftB)
  2:200: ScanMag2 ScanPhase2 + (12*ScanPhaseShiftA + 7*ScanPhaseShiftB)
  2:201: ScanMag2 ScanPhase2 + (12*ScanPhaseShiftA + 8*ScanPhaseShiftB)
  2:202: ScanMag2 ScanPhase2 + (12*ScanPhaseShiftA + 9*ScanPhaseShiftB)
  2:203: ScanMag2 ScanPhase2 + (12*ScanPhaseShiftA + 10*ScanPhaseShiftB)
  2:204: ScanMag2 ScanPhase2 + (12*ScanPhaseShiftA + 11*ScanPhaseShiftB)
  2:205: ScanMag2 ScanPhase2 + (12*ScanPhaseShiftA + 12*ScanPhaseShiftB)
  2:206: ScanMag2 ScanPhase2 + (12*ScanPhaseShiftA + 13*ScanPhaseShiftB)
  2:207: ScanMag2 ScanPhase2 + (12*ScanPhaseShiftA + 14*ScanPhaseShiftB)
  2:208: ScanMag2 ScanPhase2 + (12*ScanPhaseShiftA + 15*ScanPhaseShiftB)
  2:209: ScanMag2 ScanPhase2 + (13*ScanPhaseShiftA + 0*ScanPhaseShiftB)
  2:210: ScanMag2 ScanPhase2 + (13*ScanPhaseShiftA + 1*ScanPhaseShiftB)
  2:211: ScanMag2 ScanPhase2 + (13*ScanPhaseShiftA + 2*ScanPhaseShiftB)
  2:212: ScanMag2 ScanPhase2 + (13*ScanPhaseShiftA + 3*ScanPhaseShiftB)
  2:213: ScanMag2 ScanPhase2 + (13*ScanPhaseShiftA + 4*ScanPhaseShiftB)
  2:214: ScanMag2 ScanPhase2 + (13*ScanPhaseShiftA + 5*ScanPhaseShiftB)
  2:215: ScanMag2 ScanPhase2 + (13*ScanPhaseShiftA + 6*ScanPhaseShiftB)
  2:216: ScanMag2 ScanPhase2 + (13*ScanPhaseShiftA + 7*ScanPhaseShiftB)
  2:217: ScanMag2 ScanPhase2 + (13*ScanPhaseShiftA + 8*ScanPhaseShiftB)
  2:218: ScanMag2 ScanPhase2 + (13*ScanPhaseShiftA + 9*ScanPhaseShiftB)
  2:219: ScanMag2 ScanPhase2 + (13*ScanPhaseShiftA + 10*ScanPhaseShiftB)
  2:220: ScanMag2 ScanPhase2 + (13*ScanPhaseShiftA + 11*ScanPhaseShiftB)
  2:221: ScanMag2 ScanPhase2 + (13*ScanPhaseShiftA + 12*ScanPhaseShiftB)
  2:222: ScanMag2 ScanPhase2 + (13*ScanPhaseShiftA + 13*ScanPhaseShiftB)
  2:223: ScanMag2 ScanPhase2 + (13*ScanPhaseShiftA + 14*ScanPhaseShiftB)
  2:224: ScanMag2 ScanPhase2 + (13*ScanPhaseShiftA + 15*ScanPhaseShiftB)
  2:225: ScanMag2 ScanPhase2 + (14*ScanPhaseShiftA + 0*ScanPhaseShiftB)
  2:226: ScanMag2 ScanPhase2 + (14*ScanPhaseShiftA + 1*ScanPhaseShiftB)
  2:227: ScanMag2 ScanPhase2 + (14*ScanPhaseShiftA + 2*ScanPhaseShiftB)
  2:228: ScanMag2 ScanPhase2 + (14*ScanPhaseShiftA + 3*ScanPhaseShiftB)
  2:229: ScanMag2 ScanPhase2 + (14*ScanPhaseShiftA + 4*ScanPhaseShiftB)
  2:230: ScanMag2 ScanPhase2 + (14*ScanPhaseShiftA + 5*ScanPhaseShiftB)
  2:231: ScanMag2 ScanPhase2 + (14*ScanPhaseShiftA + 6*ScanPhaseShiftB)
  2:232: ScanMag2 ScanPhase2 + (14*ScanPhaseShiftA + 7*ScanPhaseShiftB)
  2:233: ScanMag2 ScanPhase2 + (14*ScanPhaseShiftA + 8*ScanPhaseShiftB)
  2:234: ScanMag2 ScanPhase2 + (14*ScanPhaseShiftA + 9*ScanPhaseShiftB)
  2:235: ScanMag2 ScanPhase2 + (14*ScanPhaseShiftA + 10*ScanPhaseShiftB)
  2:236: ScanMag2 ScanPhase2 + (14*ScanPhaseShiftA + 11*ScanPhaseShiftB)
  2:237: ScanMag2 ScanPhase2 + (14*ScanPhaseShiftA + 12*ScanPhaseShiftB)
  2:238: ScanMag2 ScanPhase2 + (14*ScanPhaseShiftA + 13*ScanPhaseShiftB)
  2:239: ScanMag2 ScanPhase2 + (14*ScanPhaseShiftA + 14*ScanPhaseShiftB)
  2:240: ScanMag2 ScanPhase2 + (14*ScanPhaseShiftA + 15*ScanPhaseShiftB)
  2:241: ScanMag2 ScanPhase2 + (15*ScanPhaseShiftA + 0*ScanPhaseShiftB)
  2:242: ScanMag2 ScanPhase2 + (15*ScanPhaseShiftA + 1*ScanPhaseShiftB)
  2:243: ScanMag2 ScanPhase2 + (15*ScanPhaseShiftA + 2*ScanPhaseShiftB)
  2:244: ScanMag2 ScanPhase2 + (15*ScanPhaseShiftA + 3*ScanPhaseShiftB)
  2:245: ScanMag2 ScanPhase2 + (15*ScanPhaseShiftA + 4*ScanPhaseShiftB)
  2:246: ScanMag2 ScanPhase2 + (15*ScanPhaseShiftA + 5*ScanPhaseShiftB)
  2:247: ScanMag2 ScanPhase2 + (15*ScanPhaseShiftA + 6*ScanPhaseShiftB)
  2:248: ScanMag2 ScanPhase2 + (15*ScanPhaseShiftA + 7*ScanPhaseShiftB)
  2:249: ScanMag2 ScanPhase2 + (15*ScanPhaseShiftA + 8*ScanPhaseShiftB)
  2:250: ScanMag2 ScanPhase2 + (15*ScanPhaseShiftA + 9*ScanPhaseShiftB)
  2:251: ScanMag2 ScanPhase2 + (15*ScanPhaseShiftA + 10*ScanPhaseShiftB)
  2:252: ScanMag2 ScanPhase2 + (15*ScanPhaseShiftA + 11*ScanPhaseShiftB)
  2:253: ScanMag2 ScanPhase2 + (15*ScanPhaseShiftA + 12*ScanPhaseShiftB)
  2:254: ScanMag2 ScanPhase2 + (15*ScanPhaseShiftA + 13*ScanPhaseShiftB)
  2:255: ScanMag2 ScanPhase2 + (15*ScanPhaseShiftA + 14*ScanPhaseShiftB)
  2:256: ScanMag2 ScanPhase2 + (15*ScanPhaseShiftA + 15*ScanPhaseShiftB)
radiation setups:
  Infinite Sphere1: Infinite Sphere Theta=-180deg..180deg step 1deg Phi=-180deg..180deg step 1deg
reports:
  S Parameter Plot 2: dB(S(A[1,1]1,A[1,1]1)), dB(S(A[1,1]2,A[1,1]1)), dB(S(A[1,2]1,A[1,1]1)), dB(S(A[1,2]2,A[1,1]1)), dB(S(A[1,3]1,A[1,1]1)), dB(S(A[1,3]2,A[1,1]1)), dB(S(A[1,4]1,A[1,1]1)) vs Freq on Setup1 : Sweep; markers MX1 at x=2.0559659e+10, MX2 at x=1.9263889e+10
  Gain Plot 1: dB(GainTotal) vs Phi, Theta on Setup1 : LastAdaptive, Infinite Sphere1 [Freq=18.5GHz]
  Axial Ratio Plot 1: dB(AxialRatioValue) vs Theta on Setup1 : Sweep, Infinite Sphere1 [Phi=0deg Freq=18.5GHz]; markers MX1 at x=0.0031894342
  Gain Plot 2: dB(GainLHCP), dB(GainRHCP) vs Theta on Setup1 : LastAdaptive, Infinite Sphere1 [Phi=0deg Freq=18.5GHz]; markers m1 at 2.4389878deg, m2 at -2.4274639deg, MX1 at x=0.017864168
  Axial Ratio Plot 2: dB(AxialRatioValue) vs Freq on Setup1 : Sweep, Infinite Sphere1 [Phi=0deg Theta=0deg]; markers m1 at 0deg
  Gain Plot 3: dB(GainTotal) vs Theta on Setup1 : LastAdaptive, Infinite Sphere1 [Phi=-150deg,0deg,90deg Freq=18.5GHz]
