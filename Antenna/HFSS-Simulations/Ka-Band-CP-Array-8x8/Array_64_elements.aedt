# Ansys Electronics Desktop project, version 2020.2
materials:
  Foam: permittivity=1.05 dielectric_loss_tangent=0.004
  Rogers RO4003 (tm): permittivity=3.55 dielectric_loss_tangent=0.0027
  Teflon (tm): permittivity=2.1 dielectric_loss_tangent=0.001
  copper: permeability=0.999991 conductivity=58000000
  vacuum: permittivity=1

design Single-Element-Ka2 (HFSS, DrivenModal, model units mm)
variables:
  wy = 1.02mm
  Port_loc = -2.7mm
  xd = 11mm
  h = 0.5mm
  xu = 4.1mm
  yu = 4.1mm
  H_Foam = 0.5mm
  Wx_up = 0.6mm
  L = 4.6mm
  W = 4.6mm
  wp = 0.9mm
  Lp = 0.7mm
  Wx = 0.8mm
  Scalevariation = 0.5mm
  SC_V = 1
  SC_SMA = 0.16
  d = 0mm
  Lcore = 11mm
geometry:
  Down_Sub [Rogers RO4003 (tm)] = box(corner=(-xd/2, -xd/2, 0mm), size=(xd, xd, h))
  Patch_up [copper] = rectangle(corner=(-xu/2, -yu/2, 2*h+H_Foam+0.035mm), x_size=xu, y_size=yu)
  Patch_up.thicken(0.035mm)
  Polyline2 = polyline(z=2*h+H_Foam, xy: (-xu/2, Wx_up) (-Wx_up, yu/2) (-xu/2, yu/2) (-xu/2, Wx_up), covered)
  Polyline2.thicken(1mm, both sides)
  Polyline2_1 = Polyline2.duplicate_around_axis(axis=Z, angle=180deg, total=2)
  Patch_up.subtract(Polyline2, Polyline2_1)
  Up_Sub [Rogers RO4003 (tm)] = box(corner=(-xd/2, -xd/2, h+H_Foam+0.035mm), size=(xd, xd, h))
  Patch_down_1 = rectangle(corner=(-L/2, -wp/2, h), x_size=-Lp, y_size=wp)
  Patch_down_1.thicken(-0.035mm)
  Patch_Down [copper] = Patch_down_1.duplicate_around_axis(axis=Z, angle=270deg, total=2)
  Patch_down_1_1 = Patch_down_1.copy()
  Foam [Foam] = box(corner=(-xd/2, -xd/2, h+0.035mm), size=(xd, xd, H_Foam))
  Foam.subtract(Patch_down_1_1)
  Patch = rectangle(corner=(-L/2, -W/2, h), x_size=L, y_size=W)
  Patch.thicken(0.035mm)
  Ground [copper] = rectangle(corner=(-xd/2, -xd/2, 0mm), x_size=xd, y_size=xd)
  Ground.thicken(-0.035mm)
  Polyline1 = polyline(z=h, xy: (-Wx, W/2) (-L/2, Wx) (-L/2, W/2) (-Wx, W/2), closed, covered)
  Polyline1.thicken(1mm, both sides)
  Polyline1_1 = Polyline1.duplicate_around_axis(axis=Z, angle=180deg, total=2)
  [Down_Sub, Patch_up, Up_Sub, Patch_down_1, Foam].scale(SC_V, SC_V, SC_V)
  Patch_Down.unite(Patch, Patch_down_1)
  Connector1_Shield1 = imported_body(D:\Energy Harvesting\HFSS\SMA-KHD135-1.sat)
  Connector1_Shield1.rotate(axis=Y, angle=-90deg)
  Cylinder23 = cylinder(axis=Z, base_centre=(0mm, 0mm, 14.5mm), radius=2.05mm, height=-12.5mm)
  Cylinder24 = cylinder(axis=Z, base_centre=(0mm, 0mm, 16.5mm), radius=0.65mm, height=-14.5mm)
  Cylinder23.subtract(Cylinder24)
  Connector1_Shield1.subtract(Cylinder23)
  Connector1_Shield1.move(5mm, 8.5mm, (-16.5+1) mm)
  Cylinder29 = cylinder(axis=Z, base_centre=(5mm, 8.5mm, 1mm), radius=0.65mm, height=-14.5mm)
  Connector1_Shield1.subtract(Cylinder29)
  Connector1_Shield1.move(0mm, 0mm, (4-4+0.965) mm)
  Connector1_Shield1.rotate(axis=Y, angle=180deg)
  Connector1_Shield1.rotate(axis=Z, angle=180deg)
  Connector1_Shield1.move(0mm, 17mm, 0.965mm)
  Connector1_Shield1.move(0mm, 0mm, d)
  Connector1_Shield1.move(-5mm, -8.5mm, 0.035mm)
  Connector1_Shield1.move(-0.05mm, 0mm, -6.035mm)
  Connector1_Shield1.rotate(axis=Y, angle=180deg)
  Connector1_Shield1.scale(SC_SMA, SC_SMA, SC_SMA)
  Connector1_Core1 = cylinder(axis=Z, base_centre=(5mm, 8.5mm, 13.5mm+d), radius=0.65mm, height=-Lcore)
  Cylinder34 = cylinder(axis=Z, base_centre=(0mm, 0mm, 37.705mm), radius=0.65mm, height=-5mm)
  Connector1_Core1.subtract(Cylinder34)
  Connector1_Core1.move(-5mm, -8.5mm, 0.035mm)
  Connector1_Core1.move(-0.05mm, 0mm, -6.035mm)
  Connector1_Core1.rotate(axis=Y, angle=180deg)
  Connector1_Core1.scale(SC_SMA, SC_SMA, SC_SMA)
  Teflon1 [Teflon (tm)] = cylinder(axis=Z, base_centre=(5mm, 8.5mm, 13.5mm+d), radius=2.05mm, height=-7.5mm)
  Cylinder33 = cylinder(axis=Z, base_centre=(5mm, 8.5mm, 13.5mm+d), radius=0.65mm, height=-13.535mm)
  Teflon1.subtract(Cylinder33)
  Teflon1.move(-5mm, -8.5mm, 0.035mm)
  Teflon1.move(-0.05mm, 0mm, -6.035mm)
  Teflon1.rotate(axis=Y, angle=180deg)
  Teflon1.scale(SC_SMA, SC_SMA, SC_SMA)
  [Teflon1, Connector1_Core1, Connector1_Shield1].move(Port_loc, 0mm, -0.035mm)
  Teflon2 = cylinder(axis=Z, base_centre=(5mm, 8.5mm, 13.5mm+d), radius=2.05mm, height=-9mm)
  Teflon2.move(-5mm, -8.5mm, 0.035mm)
  Teflon2.move(-0.05mm, 0mm, -6.035mm)
  Teflon2.rotate(axis=Y, angle=180deg)
  Teflon2.scale(SC_SMA, SC_SMA, SC_SMA)
  Teflon2.move(Port_loc, 0mm, -0.035mm)
  Teflon2_1 = Teflon2.duplicate_around_axis(axis=Z, angle=-90deg, total=2)
  Teflon1_1 [Teflon (tm)] = Teflon1.duplicate_around_axis(axis=Z, angle=-90deg, total=2)
  Connector1_Shield1_1 = Connector1_Shield1.duplicate_around_axis(axis=Z, angle=-90deg, total=2)
  Connector1_Core1_1 = Connector1_Core1.duplicate_around_axis(axis=Z, angle=-90deg, total=2)
  Patch_Down.subtract(Polyline1, Polyline1_1)
  [Teflon1, Teflon1_1, Patch_up, Connector1_Core1_1, Connector1_Core1, Connector1_Shield1, Connector1_Shield1_1, Patch_Down, Teflon2, Teflon2_1].rotate(axis=Z, angle=-45deg)
  Ground.subtract(Teflon2, Teflon2_1)
  Ground.unite(Connector1_Shield1_1, Connector1_Shield1)
  Patch_Down.unite(Connector1_Core1_1, Connector1_Core1)
  Patch_Down_2 = Patch_Down.copy()
  Down_Sub.subtract(Patch_Down_2)
  RadiatingSurface [vacuum] = region(absolute_offset=5.4054054mm on all sides)
boundaries and excitations:
  Open1: Radiation Objects=RadiatingSurface
  1: Lumped Port Faces=Teflon1_1.face(4 of 4) Modes{Mode1{IntLine{Teflon1_1.vertex(2 of 4) -> Teflon1_1.vertex(4 of 4)} CharImp=Zpi RenormImp=50ohm}} Impedance=50ohm
  2: Lumped Port Faces=Teflon1.face(3 of 3) Modes{Mode1{IntLine{Teflon1.edge(#12019) at -0.25 along -> Teflon1.edge(2 of 2) at 0.25 along} CharImp=Zpi RenormImp=50ohm}} Impedance=50ohm
setups:
  Setup1: HfssDriven MultipleAdaptiveFreqsSetup{AdaptAt{Frequency=16.5GHz Delta=0.02} AdaptAt{Frequency=18.5GHz Delta=0.02} AdaptAt{Frequency=20GHz Delta=0.02}} MaximumPasses=7 MinimumPasses=1 MinimumConvergedPasses=1 PercentRefinement=30 BasisOrder=-1 PortAccuracy=2 IterativeResidual=1e-06 DDMSolverResidual=0.0001 SaveRadFieldsOnly
    sweep Sweep: 16GHz to 21GHz, 300 points; Type=Interpolating SaveFields SaveRadFields InterpTolerance=0.5 InterpMaxSolns=250 InterpUsePortImped=false PassivityErrorTolerance=0.0001
source amplitudes:
  1:1: 0W 0deg
  2:1: 1W 0deg
radiation setups:
  3D: Infinite Sphere Theta=-180deg..180deg step 2deg Phi=-180deg..180deg step 2deg
  Elevation: Infinite Sphere Theta=-180deg..180deg step 1deg Phi=0deg..90deg step 90deg
  Azimuth: Infinite Sphere Theta=90deg..90deg step 0deg Phi=-180deg..180deg step 1deg
  antenna array: RegularArray NumUCells=1 NumVCells=1 CellUDist=11mm CellVDist=11mm UDirnX=1 UDirnY=0 UDirnZ=0 VDirnX=0 VDirnY=1 VDirnZ=0 FirstCellPosX=0mm FirstCellPosY=0mm FirstCellPosZ=0mm Behavior=UseScanAngle ScanAnglePhi=0deg ScanAngleTheta=0deg UDirnPhaseShift=0deg VDirnPhaseShift=0deg
reports:
  S Parameter Plot 2: dB(S(2,2)) vs Freq on Setup1 : Sweep; markers MX1 at x=1.7920566e+10
  Gain Plot 1: dB(GainTotal) vs Phi, Theta on Setup1 : LastAdaptive, 3D [Freq=18.5GHz]
  Axial Ratio Plot 1: dB(AxialRatioValue) vs Freq on Setup1 : Sweep, 3D [Theta=0deg Phi=0deg]
  Axial Ratio Plot 2: dB(AxialRatioValue) vs Theta on Setup1 : Sweep, 3D [Phi=90deg Freq=16.625GHz,17.25GHz,17.875GHz,18.5GHz,19.125GHz,19.75GHz]; dB(AxialRatioValue) vs Theta on Setup1 : LastAdaptive, 3D [Phi=90deg Freq=20GHz]; markers MX1 at x=1.0757711
  Gain Plot 10: dB(GainLHCP), dB(GainRHCP) vs Theta on Setup1 : Sweep, 3D [Phi=90deg Freq=18.5GHz]; markers MX1 at x=-1.0512266, MX2 at x=-0.0045543273, MX3 at x=1.0680908

design Ka-Array8.8 (HFSS, DrivenModal, model units mm)
variables:
  wy = 1.02mm
  Port_loc = -2.7mm
  xd = 11mm
  h = 0.5mm
  xu = 4.1mm
  yu = 4.1mm
  H_Foam = 0.5mm
  Wx_up = 0.6mm
  L = 4.6mm
  W = 4.6mm
  wp = 0.9mm
  Lp = 0.7mm
  Wx = 0.8mm
  Scalevariation = 0.5mm
  SC_V = 1
  SC_SMA = 0.16
  d = 0mm
  Lcore = 11mm
  ScanFrequency = 18500000000Hz
  ScanAngleTheta = 60deg
  ScanAnglePhi = 90deg
  ScanPhaseShiftA = -((ScanFrequency*0.0*sin(ScanAngleTheta)*cos(ScanAnglePhi)) + (ScanFrequency*2.30542952415e-10*sin(ScanAngleTheta)*sin(ScanAnglePhi))) rad
  ScanPhaseShiftB = -((ScanFrequency*2.30542952415e-10*sin(ScanAngleTheta)*cos(ScanAnglePhi)) + (ScanFrequency*0.0*sin(ScanAngleTheta)*sin(ScanAnglePhi))) rad
  ScanMag1 = 0W
  ScanPhase1 = 0deg
  ScanMag2 = 1W
  ScanPhase2 = 0deg
geometry:
  Down_Sub [Rogers RO4003 (tm)] = box(corner=(-xd/2, -xd/2, 0mm), size=(xd, xd, h))
  Patch_up [copper] = rectangle(corner=(-xu/2, -yu/2, 2*h+H_Foam+0.035mm), x_size=xu, y_size=yu)
  Patch_up.thicken(0.035mm)
  Polyline2 = polyline(z=2*h+H_Foam, xy: (-xu/2, Wx_up) (-Wx_up, yu/2) (-xu/2, yu/2) (-xu/2, Wx_up), covered)
  Polyline2.thicken(1mm, both sides)
  Polyline2_1 = Polyline2.duplicate_around_axis(axis=Z, angle=180deg, total=2)
  Patch_up.subtract(Polyline2, Polyline2_1)
  Up_Sub [Rogers RO4003 (tm)] = box(corner=(-xd/2, -xd/2, h+H_Foam+0.035mm), size=(xd, xd, h))
  Patch_down_1 = rectangle(corner=(-L/2, -wp/2, h), x_size=-Lp, y_size=wp)
  Patch_down_1.thicken(-0.035mm)
  Patch_Down [copper] = Patch_down_1.duplicate_around_axis(axis=Z, angle=270deg, total=2)
  Patch_down_1_1 = Patch_down_1.copy()
  Foam [Foam] = box(corner=(-xd/2, -xd/2, h+0.035mm), size=(xd, xd, H_Foam))
  Foam.subtract(Patch_down_1_1)
  Patch = rectangle(corner=(-L/2, -W/2, h), x_size=L, y_size=W)
  Patch.thicken(0.035mm)
  Ground [copper] = rectangle(corner=(-xd/2, -xd/2, 0mm), x_size=xd, y_size=xd)
  Ground.thicken(-0.035mm)
  Polyline1 = polyline(z=h, xy: (-Wx, W/2) (-L/2, Wx) (-L/2, W/2) (-Wx, W/2), closed, covered)
  Polyline1.thicken(1mm, both sides)
  Polyline1_1 = Polyline1.duplicate_around_axis(axis=Z, angle=180deg, total=2)
  [Down_Sub, Patch_up, Up_Sub, Patch_down_1, Foam].scale(SC_V, SC_V, SC_V)
  Patch_Down.unite(Patch, Patch_down_1)
  Connector1_Shield1 = imported_body(D:\Energy Harvesting\HFSS\SMA-KHD135-1.sat)
  Connector1_Shield1.rotate(axis=Y, angle=-90deg)
  Cylinder23 = cylinder(axis=Z, base_centre=(0mm, 0mm, 14.5mm), radius=2.05mm, height=-12.5mm)
  Cylinder24 = cylinder(axis=Z, base_centre=(0mm, 0mm, 16.5mm), radius=0.65mm, height=-14.5mm)
  Cylinder23.subtract(Cylinder24)
  Connector1_Shield1.subtract(Cylinder23)
  Connector1_Shield1.move(5mm, 8.5mm, (-16.5+1) mm)
  Cylinder29 = cylinder(axis=Z, base_centre=(5mm, 8.5mm, 1mm), radius=0.65mm, height=-14.5mm)
  Connector1_Shield1.subtract(Cylinder29)
  Connector1_Shield1.move(0mm, 0mm, (4-4+0.965) mm)
  Connector1_Shield1.rotate(axis=Y, angle=180deg)
  Connector1_Shield1.rotate(axis=Z, angle=180deg)
  Connector1_Shield1.move(0mm, 17mm, 0.965mm)
  Connector1_Shield1.move(0mm, 0mm, d)
  Connector1_Shield1.move(-5mm, -8.5mm, 0.035mm)
  Connector1_Shield1.move(-0.05mm, 0mm, -6.035mm)
  Connector1_Shield1.rotate(axis=Y, angle=180deg)
  Connector1_Shield1.scale(SC_SMA, SC_SMA, SC_SMA)
  Connector1_Core1 = cylinder(axis=Z, base_centre=(5mm, 8.5mm, 13.5mm+d), radius=0.65mm, height=-Lcore)
  Cylinder34 = cylinder(axis=Z, base_centre=(0mm, 0mm, 37.705mm), radius=0.65mm, height=-5mm)
  Connector1_Core1.subtract(Cylinder34)
  Connector1_Core1.move(-5mm, -8.5mm, 0.035mm)
  Connector1_Core1.move(-0.05mm, 0mm, -6.035mm)
  Connector1_Core1.rotate(axis=Y, angle=180deg)
  Connector1_Core1.scale(SC_SMA, SC_SMA, SC_SMA)
  Teflon1 [Teflon (tm)] = cylinder(axis=Z, base_centre=(5mm, 8.5mm, 13.5mm+d), radius=2.05mm, height=-7.5mm)
  Cylinder33 = cylinder(axis=Z, base_centre=(5mm, 8.5mm, 13.5mm+d), radius=0.65mm, height=-13.535mm)
  Teflon1.subtract(Cylinder33)
  Teflon1.move(-5mm, -8.5mm, 0.035mm)
  Teflon1.move(-0.05mm, 0mm, -6.035mm)
  Teflon1.rotate(axis=Y, angle=180deg)
  Teflon1.scale(SC_SMA, SC_SMA, SC_SMA)
  [Teflon1, Connector1_Core1, Connector1_Shield1].move(Port_loc, 0mm, -0.035mm)
  Teflon2 = cylinder(axis=Z, base_centre=(5mm, 8.5mm, 13.5mm+d), radius=2.05mm, height=-9mm)
  Teflon2.move(-5mm, -8.5mm, 0.035mm)
  Teflon2.move(-0.05mm, 0mm, -6.035mm)
  Teflon2.rotate(axis=Y, angle=180deg)
  Teflon2.scale(SC_SMA, SC_SMA, SC_SMA)
  Teflon2.move(Port_loc, 0mm, -0.035mm)
  Teflon2_1 = Teflon2.duplicate_around_axis(axis=Z, angle=-90deg, total=2)
  Teflon1_1 [Teflon (tm)] = Teflon1.duplicate_around_axis(axis=Z, angle=-90deg, total=2)
  Connector1_Shield1_1 = Connector1_Shield1.duplicate_around_axis(axis=Z, angle=-90deg, total=2)
  Connector1_Core1_1 = Connector1_Core1.duplicate_around_axis(axis=Z, angle=-90deg, total=2)
  Patch_Down.subtract(Polyline1, Polyline1_1)
  [Teflon1, Teflon1_1, Patch_up, Connector1_Core1_1, Connector1_Core1, Connector1_Shield1, Connector1_Shield1_1, Patch_Down, Teflon2, Teflon2_1].rotate(axis=Z, angle=-45deg)
  Ground.subtract(Teflon2, Teflon2_1)
  Ground.unite(Connector1_Shield1_1, Connector1_Shield1)
  Patch_Down.unite(Connector1_Core1_1, Connector1_Core1)
  Patch_Down_2 = Patch_Down.copy()
  Down_Sub.subtract(Patch_Down_2)
  RadiatingSurface [vacuum] = region(absolute_offset: +X=0mm, -X=0mm, +Y=0mm, -Y=0mm, +Z=5.4054054mm, -Z=1mm)
boundaries and excitations:
  LatticePair1: Lattice Pair Faces=RadiatingSurface.face(-y, +y) CoordSysVector{RadiatingSurface.vertex(4 of 8) -> RadiatingSurface.vertex(7 of 8)} ReverseV PhaseDelay=UseScanAngle Phi=0deg Theta=0deg
  LatticePair2: Lattice Pair Faces=RadiatingSurface.face(-x, +x) CoordSysVector{RadiatingSurface.vertex(3 of 8) -> RadiatingSurface.vertex(8 of 8)} ReverseV PhaseDelay=UseScanAngle Phi=0deg Theta=0deg
  Rad1: Radiation Faces=RadiatingSurface.face(+z, -z)
  1: Lumped Port Faces=Teflon1_1.face(4 of 4) Modes{Mode1{IntLine{Teflon1_1.vertex(2 of 4) -> Teflon1_1.vertex(4 of 4)} CharImp=Zpi RenormImp=50ohm}} Impedance=50ohm
  2: Lumped Port Faces=Teflon1.face(3 of 3) Modes{Mode1{IntLine{Teflon1.edge(#12019) at -0.25 along -> Teflon1.edge(2 of 2) at 0.25 along} CharImp=Zpi RenormImp=50ohm}} Impedance=50ohm
array:
  Type=Regular Name=A UseAirObjects RowMasterBnd=LatticePair1 ColumnMasterBnd=LatticePair2 RowDimension=8 ColumnDimension=8 RenderType=0 Padding=1 PostProcessRow=8 PostProcessCol=8
setups:
  Setup1: HfssDriven Frequency=18.5GHz MaxDeltaS=0.02 MaximumPasses=6 MinimumPasses=1 MinimumConvergedPasses=1 PercentRefinement=30 BasisOrder=-1 PortAccuracy=2 UseDomains DDMSolverResidual=0.0001 SaveRadFieldsOnly
    sweep Sweep: 16GHz to 21GHz, 401 points; Type=Interpolating SaveFields SaveRadFields InterpTolerance=0.5 InterpMaxSolns=250 InterpUsePortImped=false PassivityErrorTolerance=0.0001
source amplitudes:
  1:1: ScanMag1 ScanPhase1 + (0*ScanPhaseShiftA + 0*ScanPhaseShiftB)
  1:2: ScanMag1 ScanPhase1 + (0*ScanPhaseShiftA + 1*ScanPhaseShiftB)
  1:3: ScanMag1 ScanPhase1 + (0*ScanPhaseShiftA + 2*ScanPhaseShiftB)
  1:4: ScanMag1 ScanPhase1 + (0*ScanPhaseShiftA + 3*ScanPhaseShiftB)
  1:5: ScanMag1 ScanPhase1 + (0*ScanPhaseShiftA + 4*ScanPhaseShiftB)
  1:6: ScanMag1 ScanPhase1 + (0*ScanPhaseShiftA + 5*ScanPhaseShiftB)
  1:7: ScanMag1 ScanPhase1 + (0*ScanPhaseShiftA + 6*ScanPhaseShiftB)
  1:8: ScanMag1 ScanPhase1 + (0*ScanPhaseShiftA + 7*ScanPhaseShiftB)
  1:9: ScanMag1 ScanPhase1 + (1*ScanPhaseShiftA + 0*ScanPhaseShiftB)
  1:10: ScanMag1 ScanPhase1 + (1*ScanPhaseShiftA + 1*ScanPhaseShiftB)
  1:11: ScanMag1 ScanPhase1 + (1*ScanPhaseShiftA + 2*ScanPhaseShiftB)
  1:12: ScanMag1 ScanPhase1 + (1*ScanPhaseShiftA + 3*ScanPhaseShiftB)
  1:13: ScanMag1 ScanPhase1 + (1*ScanPhaseShiftA + 4*ScanPhaseShiftB)
  1:14: ScanMag1 ScanPhase1 + (1*ScanPhaseShiftA + 5*ScanPhaseShiftB)
  1:15: ScanMag1 ScanPhase1 + (1*ScanPhaseShiftA + 6*ScanPhaseShiftB)
  1:16: ScanMag1 ScanPhase1 + (1*ScanPhaseShiftA + 7*ScanPhaseShiftB)
  1:17: ScanMag1 ScanPhase1 + (2*ScanPhaseShiftA + 0*ScanPhaseShiftB)
  1:18: ScanMag1 ScanPhase1 + (2*ScanPhaseShiftA + 1*ScanPhaseShiftB)
  1:19: ScanMag1 ScanPhase1 + (2*ScanPhaseShiftA + 2*ScanPhaseShiftB)
  1:20: ScanMag1 ScanPhase1 + (2*ScanPhaseShiftA + 3*ScanPhaseShiftB)
  1:21: ScanMag1 ScanPhase1 + (2*ScanPhaseShiftA + 4*ScanPhaseShiftB)
  1:22: ScanMag1 ScanPhase1 + (2*ScanPhaseShiftA + 5*ScanPhaseShiftB)
  1:23: ScanMag1 ScanPhase1 + (2*ScanPhaseShiftA + 6*ScanPhaseShiftB)
  1:24: ScanMag1 ScanPhase1 + (2*ScanPhaseShiftA + 7*ScanPhaseShiftB)
  1:25: ScanMag1 ScanPhase1 + (3*ScanPhaseShiftA + 0*ScanPhaseShiftB)
  1:26: ScanMag1 ScanPhase1 + (3*ScanPhaseShiftA + 1*ScanPhaseShiftB)
  1:27: ScanMag1 ScanPhase1 + (3*ScanPhaseShiftA + 2*ScanPhaseShiftB)
  1:28: ScanMag1 ScanPhase1 + (3*ScanPhaseShiftA + 3*ScanPhaseShiftB)
  1:29: ScanMag1 ScanPhase1 + (3*ScanPhaseShiftA + 4*ScanPhaseShiftB)
  1:30: ScanMag1 ScanPhase1 + (3*ScanPhaseShiftA + 5*ScanPhaseShiftB)
  1:31: ScanMag1 ScanPhase1 + (3*ScanPhaseShiftA + 6*ScanPhaseShiftB)
  1:32: ScanMag1 ScanPhase1 + (3*ScanPhaseShiftA + 7*ScanPhaseShiftB)
  1:33: ScanMag1 ScanPhase1 + (4*ScanPhaseShiftA + 0*ScanPhaseShiftB)
  1:34: ScanMag1 ScanPhase1 + (4*ScanPhaseShiftA + 1*ScanPhaseShiftB)
  1:35: ScanMag1 ScanPhase1 + (4*ScanPhaseShiftA + 2*ScanPhaseShiftB)
  1:36: ScanMag1 ScanPhase1 + (4*ScanPhaseShiftA + 3*ScanPhaseShiftB)
  1:37: ScanMag1 ScanPhase1 + (4*ScanPhaseShiftA + 4*ScanPhaseShiftB)
  1:38: ScanMag1 ScanPhase1 + (4*ScanPhaseShiftA + 5*ScanPhaseShiftB)
  1:39: ScanMag1 ScanPhase1 + (4*ScanPhaseShiftA + 6*ScanPhaseShiftB)
  1:40: ScanMag1 ScanPhase1 + (4*ScanPhaseShiftA + 7*ScanPhaseShiftB)
  1:41: ScanMag1 ScanPhase1 + (5*ScanPhaseShiftA + 0*ScanPhaseShiftB)
  1:42: ScanMag1 ScanPhase1 + (5*ScanPhaseShiftA + 1*ScanPhaseShiftB)
  1:43: ScanMag1 ScanPhase1 + (5*ScanPhaseShiftA + 2*ScanPhaseShiftB)
  1:44: ScanMag1 ScanPhase1 + (5*ScanPhaseShiftA + 3*ScanPhaseShiftB)
  1:45: ScanMag1 ScanPhase1 + (5*ScanPhaseShiftA + 4*ScanPhaseShiftB)
  1:46: ScanMag1 ScanPhase1 + (5*ScanPhaseShiftA + 5*ScanPhaseShiftB)
  1:47: ScanMag1 ScanPhase1 + (5*ScanPhaseShiftA + 6*ScanPhaseShiftB)
  1:48: ScanMag1 ScanPhase1 + (5*ScanPhaseShiftA + 7*ScanPhaseShiftB)
  1:49: ScanMag1 ScanPhase1 + (6*ScanPhaseShiftA + 0*ScanPhaseShiftB)
  1:50: ScanMag1 ScanPhase1 + (6*ScanPhaseShiftA + 1*ScanPhaseShiftB)
  1:51: ScanMag1 ScanPhase1 + (6*ScanPhaseShiftA + 2*ScanPhaseShiftB)
  1:52: ScanMag1 ScanPhase1 + (6*ScanPhaseShiftA + 3*ScanPhaseShiftB)
  1:53: ScanMag1 ScanPhase1 + (6*ScanPhaseShiftA + 4*ScanPhaseShiftB)
  1:54: ScanMag1 ScanPhase1 + (6*ScanPhaseShiftA + 5*ScanPhaseShiftB)
  1:55: ScanMag1 ScanPhase1 + (6*ScanPhaseShiftA + 6*ScanPhaseShiftB)
  1:56: ScanMag1 ScanPhase1 + (6*ScanPhaseShiftA + 7*ScanPhaseShiftB)
  1:57: ScanMag1 ScanPhase1 + (7*ScanPhaseShiftA + 0*ScanPhaseShiftB)
  1:58: ScanMag1 ScanPhase1 + (7*ScanPhaseShiftA + 1*ScanPhaseShiftB)
  1:59: ScanMag1 ScanPhase1 + (7*ScanPhaseShiftA + 2*ScanPhaseShiftB)
  1:60: ScanMag1 ScanPhase1 + (7*ScanPhaseShiftA + 3*ScanPhaseShiftB)
  1:61: ScanMag1 ScanPhase1 + (7*ScanPhaseShiftA + 4*ScanPhaseShiftB)
  1:62: ScanMag1 ScanPhase1 + (7*ScanPhaseShiftA + 5*ScanPhaseShiftB)
  1:63: ScanMag1 ScanPhase1 + (7*ScanPhaseShiftA + 6*ScanPhaseShiftB)
  1:64: ScanMag1 ScanPhase1 + (7*ScanPhaseShiftA + 7*ScanPhaseShiftB)
  2:1: ScanMag2 ScanPhase2 + (0*ScanPhaseShiftA + 0*ScanPhaseShiftB)
  2:2: ScanMag2 ScanPhase2 + (0*ScanPhaseShiftA + 1*ScanPhaseShiftB)
  2:3: ScanMag2 ScanPhase2 + (0*ScanPhaseShiftA + 2*ScanPhaseShiftB)
  2:4: ScanMag2 ScanPhase2 + (0*ScanPhaseShiftA + 3*ScanPhaseShiftB)
  2:5: ScanMag2 ScanPhase2 + (0*ScanPhaseShiftA + 4*ScanPhaseShiftB)
  2:6: ScanMag2 ScanPhase2 + (0*ScanPhaseShiftA + 5*ScanPhaseShiftB)
  2:7: ScanMag2 ScanPhase2 + (0*ScanPhaseShiftA + 6*ScanPhaseShiftB)
  2:8: ScanMag2 ScanPhase2 + (0*ScanPhaseShiftA + 7*ScanPhaseShiftB)
  2:9: ScanMag2 ScanPhase2 + (1*ScanPhaseShiftA + 0*ScanPhaseShiftB)
  2:10: ScanMag2 ScanPhase2 + (1*ScanPhaseShiftA + 1*ScanPhaseShiftB)
  2:11: ScanMag2 ScanPhase2 + (1*ScanPhaseShiftA + 2*ScanPhaseShiftB)
  2:12: ScanMag2 ScanPhase2 + (1*ScanPhaseShiftA + 3*ScanPhaseShiftB)
  2:13: ScanMag2 ScanPhase2 + (1*ScanPhaseShiftA + 4*ScanPhaseShiftB)
  2:14: ScanMag2 ScanPhase2 + (1*ScanPhaseShiftA + 5*ScanPhaseShiftB)
  2:15: ScanMag2 ScanPhase2 + (1*ScanPhaseShiftA + 6*ScanPhaseShiftB)
  2:16: ScanMag2 ScanPhase2 + (1*ScanPhaseShiftA + 7*ScanPhaseShiftB)
  2:17: ScanMag2 ScanPhase2 + (2*ScanPhaseShiftA + 0*ScanPhaseShiftB)
  2:18: ScanMag2 ScanPhase2 + (2*ScanPhaseShiftA + 1*ScanPhaseShiftB)
  2:19: ScanMag2 ScanPhase2 + (2*ScanPhaseShiftA + 2*ScanPhaseShiftB)
  2:20: ScanMag2 ScanPhase2 + (2*ScanPhaseShiftA + 3*ScanPhaseShiftB)
  2:21: ScanMag2 ScanPhase2 + (2*ScanPhaseShiftA + 4*ScanPhaseShiftB)
  2:22: ScanMag2 ScanPhase2 + (2*ScanPhaseShiftA + 5*ScanPhaseShiftB)
  2:23: ScanMag2 ScanPhase2 + (2*ScanPhaseShiftA + 6*ScanPhaseShiftB)
  2:24: ScanMag2 ScanPhase2 + (2*ScanPhaseShiftA + 7*ScanPhaseShiftB)
  2:25: ScanMag2 ScanPhase2 + (3*ScanPhaseShiftA + 0*ScanPhaseShiftB)
  2:26: ScanMag2 ScanPhase2 + (3*ScanPhaseShiftA + 1*ScanPhaseShiftB)
  2:27: ScanMag2 ScanPhase2 + (3*ScanPhaseShiftA + 2*ScanPhaseShiftB)
  2:28: ScanMag2 ScanPhase2 + (3*ScanPhaseShiftA + 3*ScanPhaseShiftB)
  2:29: ScanMag2 ScanPhase2 + (3*ScanPhaseShiftA + 4*ScanPhaseShiftB)
  2:30: ScanMag2 ScanPhase2 + (3*ScanPhaseShiftA + 5*ScanPhaseShiftB)
  2:31: ScanMag2 ScanPhase2 + (3*ScanPhaseShiftA + 6*ScanPhaseShiftB)
  2:32: ScanMag2 ScanPhase2 + (3*ScanPhaseShiftA + 7*ScanPhaseShiftB)
  2:33: ScanMag2 ScanPhase2 + (4*ScanPhaseShiftA + 0*ScanPhaseShiftB)
  2:34: ScanMag2 ScanPhase2 + (4*ScanPhaseShiftA + 1*ScanPhaseShiftB)
  2:35: ScanMag2 ScanPhase2 + (4*ScanPhaseShiftA + 2*ScanPhaseShiftB)
  2:36: ScanMag2 ScanPhase2 + (4*ScanPhaseShiftA + 3*ScanPhaseShiftB)
  2:37: ScanMag2 ScanPhase2 + (4*ScanPhaseShiftA + 4*ScanPhaseShiftB)
  2:38: ScanMag2 ScanPhase2 + (4*ScanPhaseShiftA + 5*ScanPhaseShiftB)
  2:39: ScanMag2 ScanPhase2 + (4*ScanPhaseShiftA + 6*ScanPhaseShiftB)
  2:40: ScanMag2 ScanPhase2 + (4*ScanPhaseShiftA + 7*ScanPhaseShiftB)
  2:41: ScanMag2 ScanPhase2 + (5*ScanPhaseShiftA + 0*ScanPhaseShiftB)
  2:42: ScanMag2 ScanPhase2 + (5*ScanPhaseShiftA + 1*ScanPhaseShiftB)
  2:43: ScanMag2 ScanPhase2 + (5*ScanPhaseShiftA + 2*ScanPhaseShiftB)
  2:44: ScanMag2 ScanPhase2 + (5*ScanPhaseShiftA + 3*ScanPhaseShiftB)
  2:45: ScanMag2 ScanPhase2 + (5*ScanPhaseShiftA + 4*ScanPhaseShiftB)
  2:46: ScanMag2 ScanPhase2 + (5*ScanPhaseShiftA + 5*ScanPhaseShiftB)
  2:47: ScanMag2 ScanPhase2 + (5*ScanPhaseShiftA + 6*ScanPhaseShiftB)
  2:48: ScanMag2 ScanPhase2 + (5*ScanPhaseShiftA + 7*ScanPhaseShiftB)
  2:49: ScanMag2 ScanPhase2 + (6*ScanPhaseShiftA + 0*ScanPhaseShiftB)
  2:50: ScanMag2 ScanPhase2 + (6*ScanPhaseShiftA + 1*ScanPhaseShiftB)
  2:51: ScanMag2 ScanPhase2 + (6*ScanPhaseShiftA + 2*ScanPhaseShiftB)
  2:52: ScanMag2 ScanPhase2 + (6*ScanPhaseShiftA + 3*ScanPhaseShiftB)
  2:53: ScanMag2 ScanPhase2 + (6*ScanPhaseShiftA + 4*ScanPhaseShiftB)
  2:54: ScanMag2 ScanPhase2 + (6*ScanPhaseShiftA + 5*ScanPhaseShiftB)
  2:55: ScanMag2 ScanPhase2 + (6*ScanPhaseShiftA + 6*ScanPhaseShiftB)
  2:56: ScanMag2 ScanPhase2 + (6*ScanPhaseShiftA + 7*ScanPhaseShiftB)
  2:57: ScanMag2 ScanPhase2 + (7*ScanPhaseShiftA + 0*ScanPhaseShiftB)
  2:58: ScanMag2 ScanPhase2 + (7*ScanPhaseShiftA + 1*ScanPhaseShiftB)
  2:59: ScanMag2 ScanPhase2 + (7*ScanPhaseShiftA + 2*ScanPhaseShiftB)
  2:60: ScanMag2 ScanPhase2 + (7*ScanPhaseShiftA + 3*ScanPhaseShiftB)
  2:61: ScanMag2 ScanPhase2 + (7*ScanPhaseShiftA + 4*ScanPhaseShiftB)
  2:62: ScanMag2 ScanPhase2 + (7*ScanPhaseShiftA + 5*ScanPhaseShiftB)
  2:63: ScanMag2 ScanPhase2 + (7*ScanPhaseShiftA + 6*ScanPhaseShiftB)
  2:64: ScanMag2 ScanPhase2 + (7*ScanPhaseShiftA + 7*ScanPhaseShiftB)
radiation setups:
  Infinite Sphere1: Infinite Sphere Theta=-180deg..180deg step 1deg Phi=-180deg..180deg step 1deg
reports:
  S Parameter Plot 2: dB(S(A[1,1]1,A[1,1]1)), dB(S(A[1,2]1,A[1,1]1)), dB(S(A[1,2]2,A[1,1]1)) vs Freq on Setup1 : Sweep; markers MX1 at x=2.0559659e+10, MX2 at x=1.9263889e+10
  Gain Plot 1: dB(GainTotal) vs Phi, Theta on Setup1 : LastAdaptive, Infinite Sphere1 [Freq=18.5GHz]
  Axial Ratio Plot 1: dB(AxialRatioValue) vs Theta on Setup1 : LastAdaptive, Infinite Sphere1 [Phi=90deg Freq=all]; markers MX1 at x=0.88592259
  Gain Plot 2: dB(GainLHCP), dB(GainRHCP) vs Theta on Setup1 : LastAdaptive, Infinite Sphere1 [Phi=90deg Freq=18.5GHz]; markers MX1 at x=1.0585523
  Axial Ratio Plot 2: dB(AxialRatioValue) vs Freq on Setup1 : Sweep, Infinite Sphere1 [Theta=0deg Phi=90deg]; markers MX1 at x=1.7819392e+10
  Gain Plot 3: dB(GainTotal) vs Theta on Setup1 : LastAdaptive, Infinite Sphere1 [Phi=-150deg,0deg,90deg Freq=18.5GHz]
